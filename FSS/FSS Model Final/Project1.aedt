# Ansys Electronics Desktop project, version 2022.2
materials:
  vacuum: permittivity=1
  Rogers RT/duroid 5880 (tm): permittivity=2.2 dielectric_loss_tangent=0.0009
  copper: permeability=0.999991 conductivity=58000000
  air: permittivity=1.0006 permeability=1.0000004

design Figure1 (HFSS, DrivenTerminal, model units mm)
variables:
  Size = 10mm
  h = 0.254mm
  w0 = 0.3mm
  r0 = 2mm
  r1 = 0.15mm
geometry:
  Box1 [Rogers RT/duroid 5880 (tm)] = box(corner=(-Size/2, Size/2, 0mm), size=(Size, Size, h))
  Connection_Top [copper] = rectangle(corner=(0, Size-(w0/2), h), x_size=Size/2, y_size=w0)
  Semi_Bottom [copper] = cylinder(axis=Z, base_centre=(Size/2, Size, 0mm), radius=r1, height=h)
  Box2 = box(corner=(Size/2, Size-(r1), 0mm), size=(2*r1, 2*r1, h))
  Semi_Bottom.subtract(Box2)
  Circle1 = circle(normal=Z, centre=(0, Size, h), radius=r0)
  Connection_Top.unite(Circle1)
  coordinate_system RelativeCS1 = origin=(0mm, Size, h/2) x=(1mm, 0mm, 0mm) y=(0mm, 1mm, 0mm)
  Connection_Bottom [copper] = Connection_Top.duplicate_mirror(point=(0mm, 0mm, 0), normal=(0, 0, -1)) in RelativeCS1
  Connection_Bottom.rotate(axis=Z, angle=180deg) in RelativeCS1
  Semi_Bottom_1 [copper] = Semi_Bottom.duplicate_around_axis(axis=Z, angle=180deg, total=2) in RelativeCS1
  Semi_Bottom_1.move(0mm, 0mm, 0) in RelativeCS1
  [Connection_Top, Connection_Bottom].thicken(0.01mm)
  Box3 [air] = box(corner=(-Size/2, -Size/2, -Size/2), size=(Size, Size, Size)) in RelativeCS1

design Figure8(b) (HFSS, DrivenTerminal, model units mm)
variables:
  Size_SB = 4.3mm
  s0 = 0.3mm
  r0 = 1.02mm
  h0 = 0.254mm
  w1 = 0.12mm
  s3 = 0.26mm
  l3 = 0.96mm
  s1 = 0.2mm
  l2 = 1.18mm
  l1 = 1.28mm
  l0 = 1.52mm
  w0 = 0.06mm
  r1 = 0.2mm
  d1 = 0.2mm
  x0 = 0.83mm
  y0 = 0.83mm
  s4 = 0.3mm
  thick1 = 0.026mm
  left_bottom = 0.2mm
geometry:
  Box1 [Rogers RT/duroid 5880 (tm)] = box(corner=(-Size_SB/2, -Size_SB/2, 0mm), size=(Size_SB, Size_SB, h0))
  Top_Red = circle(normal=Z, centre=(x0, -y0, h0), radius=r0)
  Polyline3 = polyline(z=h0, xy: (x0, -y0) (x0, -y0+r0+s3+w1) (x0+l3, -y0+r0+s3+w1) (x0+l3, -y0+r0+s3+w1+s1) (x0+l3-l2, -y0+r0+s3+w1+s1) (x0+l3-l2, -y0+r0+s3+w1+s1+2*w1+s1) (x0+l3, -y0+r0+s3+w1+s1+2*w1+s1) (x0+l3, -y0+r0+s3+w1+s1+2*w1+2*s1) (x0+l3-l1, -y0+r0+s3+w1+s1+2*w1+2*s1) (x0+l3-l1, -y0+r0+s3+w1+s1+4*w1+3*s1) (Size_SB/2-w0, -y0+r0+s3+w1+s1+4*w1+3*s1))
  Polyline4 [copper] = polyline((x0, -y0, h0) (x0+w1, -y0, h0))
  Polyline4.sweep_along_path(Polyline3)
  Polyline4.unite(Top_Red)
  Polyline5 = polyline((Size_SB/2-w0/2, -y0+r0+s3+w1+s1+3*w1+3*s1+w1, h0) (Size_SB/2-w0/2, d1/2, h0))
  Polyline6 [copper] = polyline((Size_SB/2-w0, -y0+r0+s3+w1+s1+3*w1+3*s1, h0) (Size_SB/2, -y0+r0+s3+w1+s1+3*w1+3*s1, h0))
  Polyline6.sweep_along_path(Polyline5)
  Polyline12 = polyline((0.83mm, 0.45mm, 0.254mm) (0.83mm, 0.45mm, h0+thick1))
  Polyline4.sweep_along_path(Polyline12)
  Polyline17 = polyline((Size_SB/2, -r1+(r1-d1/2)/2, h0) (2mm, 1.4936989e-17mm, 0.254mm) (2.15mm, 0.15mm, 0.254mm), AngularArc from point 0 over 3 centre=(Size_SB/2, 0mm, h0) angle=-180deg plane=XY)
  Polyline18 [copper] = polyline((Size_SB/2, -r1, h0) (Size_SB/2, -d1/2, h0))
  Polyline18.sweep_along_path(Polyline17)
  Circle2 [copper] = circle(normal=Z, centre=(Size_SB/2, 0mm, h0), radius=d1/2)
  Rectangle1 = rectangle(corner=(Size_SB/2, -d1/2, h0), x_size=d1/2, y_size=d1)
  Circle2.subtract(Rectangle1)
  [Circle2, Polyline18].thicken(0.026mm)
  Polyline21 = polyline((Size_SB/2-w0/2, -y0+r0+s3+w1+s1+3*w1+3*s1, h0) (Size_SB/2-w0/2, -y0+r0+s3+w1+s1+3*w1+3*s1, h0+thick1))
  Polyline6.sweep_along_path(Polyline21)
  Polyline4_1 [copper] = Polyline4.duplicate_around_axis(axis=Z, angle=180deg, total=2)
  Polyline18_1 [copper] = Polyline18.duplicate_around_axis(axis=Z, angle=90deg, total=2)
  Circle2_1 [copper] = Circle2.duplicate_around_axis(axis=Z, angle=90deg, total=2)
  Polyline22 = polyline((-Size_SB/2, Size_SB/2-w0/2, h0) (-d1/2, Size_SB/2-w0/2, h0))
  Polyline23 [copper] = polyline((-d1/2, Size_SB/2-w0, h0) (-d1/2, Size_SB/2, h0))
  Polyline23.sweep_along_path(Polyline22)
  Polyline6_1 [copper] = Polyline6.duplicate_around_axis(axis=Z, angle=180deg, total=2)
  Circle2_2 [copper] = Circle2.duplicate_around_axis(axis=Z, angle=180deg, total=2)
  Polyline18_2 [copper] = Polyline18.duplicate_around_axis(axis=Z, angle=180deg, total=2)
  [Polyline6_1, Circle2_2, Polyline18_2].rotate(axis=X, angle=180deg)
  [Polyline6_1, Circle2_2, Polyline18_2].rotate(axis=Y, angle=180deg)
  [Polyline6_1, Circle2_2, Polyline18_2].rotate(axis=Z, angle=180deg)
  [Polyline6_1, Polyline18_2, Circle2_2].rotate(axis=X, angle=180deg)
  [Polyline18_2, Circle2_2, Polyline6_1].move(0mm, 0mm, 2*h0+thick1)
  Polyline24 = polyline((-0.6125mm, 2.15mm, 0.254mm) (-0.6125mm, 2.15mm, h0 + thick1))
  Polyline23.sweep_along_path(Polyline24)
  Polyline23_1 [copper] = Polyline23.duplicate_around_axis(axis=Z, angle=180deg, total=2)
  Circle2_1_1 [copper] = Circle2_1.duplicate_around_axis(axis=Z, angle=180deg, total=2)
  Polyline18_1_1 [copper] = Polyline18_1.duplicate_around_axis(axis=Z, angle=180deg, total=2)
  [Polyline18_1_1, Circle2_1_1, Polyline23_1].rotate(axis=Y, angle=180deg)
  [Polyline23_1, Circle2_1_1, Polyline18_1_1].move(0mm, 0mm, 2*h0+thick1)
  Polyline25 = polyline((-Size_SB/2+w0/2, -Size_SB/2+w0, h0) (-Size_SB/2+w0/2, -Size_SB/2+s0+w1, h0))
  Polyline26 [copper] = polyline((-Size_SB/2, -Size_SB/2+w0, h0) (-Size_SB/2+w0, -Size_SB/2+w0, h0))
  Polyline26.sweep_along_path(Polyline25)
  Polyline27 = polyline((-Size_SB/2+w0, -Size_SB/2+w0, h0) (-Size_SB/2+w0, -Size_SB/2+w0, h0+thick1))
  Polyline26.sweep_along_path(Polyline27)
  Polyline28 = polyline((Size_SB/2-w0/2, -Size_SB/2, h0) (Size_SB/2-w0/2, -Size_SB/2+left_bottom, h0))
  Polyline29 [copper] = polyline((Size_SB/2-w0, -Size_SB/2+left_bottom, h0) (Size_SB/2, -Size_SB/2+left_bottom, h0))
  Polyline29.sweep_along_path(Polyline28)
  Polyline30 = polyline((Size_SB/2-w0/2, -Size_SB/2+left_bottom, h0) (Size_SB/2-w0/2, -Size_SB/2+left_bottom, h0+thick1))
  Polyline29.sweep_along_path(Polyline30)

design Figure8(c) (HFSS, DrivenTerminal, model units mm)
variables:
  Size_SB = 4.3mm
  s0 = 0.3mm
  r0 = 1.02mm
  h0 = 0.254mm
  w1 = 0.12mm
  s3 = 0.26mm
  l3 = 0.96mm
  s1 = 0.2mm
  l2 = 1.18mm
  l1 = 1.28mm
  l0 = 1.52mm
  w0 = 0.06mm
  r1 = 0.2mm
  d1 = 0.2mm
  x0 = 0.83mm
  y0 = 0.83mm
  s4 = 0.3mm
  thick1 = 0.026mm
  left_bottom = 0.2mm
geometry:
  Box1 [Rogers RT/duroid 5880 (tm)] = box(corner=(-Size_SB/2, -Size_SB/2, 0mm), size=(Size_SB, Size_SB, h0))
  Polyline4 [copper] = polyline((x0, -y0, h0) (x0+w1, -y0, h0))
  Polyline3 = polyline(z=h0, xy: (x0, -y0) (x0, -y0+r0+s3+w1) (x0+l3, -y0+r0+s3+w1) (x0+l3, -y0+r0+s3+w1+s1) (x0+l3-l2, -y0+r0+s3+w1+s1) (x0+l3-l2, -y0+r0+s3+w1+s1+2*w1+s1) (x0+l3, -y0+r0+s3+w1+s1+2*w1+s1) (x0+l3, -y0+r0+s3+w1+s1+2*w1+2*s1) (x0+l3-l1, -y0+r0+s3+w1+s1+2*w1+2*s1) (x0+l3-l1, -y0+r0+s3+w1+s1+4*w1+3*s1) (Size_SB/2-w0, -y0+r0+s3+w1+s1+4*w1+3*s1))
  Polyline4.sweep_along_path(Polyline3)
  Top_Red = circle(normal=Z, centre=(x0, -y0, h0), radius=r0)
  Polyline4.unite(Top_Red)
  Polyline12 = polyline((0.83mm, 0.45mm, 0.254mm) (0.83mm, 0.45mm, h0+thick1))
  Polyline4.sweep_along_path(Polyline12)
  Polyline4_1 [copper] = Polyline4.duplicate_around_axis(axis=Z, angle=180deg, total=2)
  Polyline6 [copper] = polyline((Size_SB/2-w0, -y0+r0+s3+w1+s1+3*w1+3*s1, h0) (Size_SB/2, -y0+r0+s3+w1+s1+3*w1+3*s1, h0))
  Polyline5 = polyline((Size_SB/2-w0/2, -y0+r0+s3+w1+s1+3*w1+3*s1+w1, h0) (Size_SB/2-w0/2, d1/2, h0))
  Polyline6.sweep_along_path(Polyline5)
  Polyline21 = polyline((Size_SB/2-w0/2, -y0+r0+s3+w1+s1+3*w1+3*s1, h0) (Size_SB/2-w0/2, -y0+r0+s3+w1+s1+3*w1+3*s1, h0+thick1))
  Polyline6.sweep_along_path(Polyline21)
  Polyline6_1 [copper] = Polyline6.duplicate_around_axis(axis=Z, angle=180deg, total=2)
  Polyline18 [copper] = polyline((Size_SB/2, -r1, h0) (Size_SB/2, -d1/2, h0))
  Polyline17 = polyline((Size_SB/2, -r1+(r1-d1/2)/2, h0) (2mm, 1.4936989e-17mm, 0.254mm) (2.15mm, 0.15mm, 0.254mm), AngularArc from point 0 over 3 centre=(Size_SB/2, 0mm, h0) angle=-180deg plane=XY)
  Polyline18.sweep_along_path(Polyline17)
  Polyline18.thicken(0.026mm)
  Polyline18_1 [copper] = Polyline18.duplicate_around_axis(axis=Z, angle=90deg, total=2)
  Polyline18_2 [copper] = Polyline18.duplicate_around_axis(axis=Z, angle=180deg, total=2)
  Circle2 [copper] = circle(normal=Z, centre=(Size_SB/2, 0mm, h0), radius=d1/2)
  Rectangle1 = rectangle(corner=(Size_SB/2, -d1/2, h0), x_size=d1/2, y_size=d1)
  Circle2.subtract(Rectangle1)
  Circle2.thicken(0.026mm)
  Circle2_1 [copper] = Circle2.duplicate_around_axis(axis=Z, angle=90deg, total=2)
  Circle2_2 [copper] = Circle2.duplicate_around_axis(axis=Z, angle=180deg, total=2)
  Polyline18_1_1 [copper] = Polyline18_1.duplicate_around_axis(axis=Z, angle=180deg, total=2)
  Circle2_1_1 [copper] = Circle2_1.duplicate_around_axis(axis=Z, angle=180deg, total=2)
  Polyline23 [copper] = polyline((-d1/2, Size_SB/2-w0, h0) (-d1/2, Size_SB/2, h0))
  Polyline22 = polyline((-Size_SB/2, Size_SB/2-w0/2, h0) (-d1/2, Size_SB/2-w0/2, h0))
  Polyline23.sweep_along_path(Polyline22)
  Polyline24 = polyline((-0.6125mm, 2.15mm, 0.254mm) (-0.6125mm, 2.15mm, h0 + thick1))
  Polyline23.sweep_along_path(Polyline24)
  Polyline23_1 [copper] = Polyline23.duplicate_around_axis(axis=Z, angle=180deg, total=2)
  Polyline6_1.rotate(axis=X, angle=180deg)
  Polyline6_1.rotate(axis=Y, angle=180deg)
  Polyline6_1.rotate(axis=Z, angle=180deg)
  Polyline6_1.rotate(axis=X, angle=180deg)
  Polyline6_1.move(0mm, 0mm, 2*h0+thick1)
  Circle2_2.rotate(axis=X, angle=180deg)
  Circle2_2.rotate(axis=Y, angle=180deg)
  Circle2_2.rotate(axis=Z, angle=180deg)
  Circle2_2.rotate(axis=X, angle=180deg)
  Circle2_2.move(0mm, 0mm, 2*h0+thick1)
  Polyline18_2.rotate(axis=X, angle=180deg)
  Polyline18_2.rotate(axis=Y, angle=180deg)
  Polyline18_2.rotate(axis=Z, angle=180deg)
  Polyline18_2.rotate(axis=X, angle=180deg)
  Polyline18_2.move(0mm, 0mm, 2*h0+thick1)
  Polyline23_1.rotate(axis=Y, angle=180deg)
  Polyline23_1.move(0mm, 0mm, 2*h0+thick1)
  Circle2_1_1.rotate(axis=Y, angle=180deg)
  Circle2_1_1.move(0mm, 0mm, 2*h0+thick1)
  Polyline18_1_1.rotate(axis=Y, angle=180deg)
  Polyline18_1_1.move(0mm, 0mm, 2*h0+thick1)
  Polyline26 [copper] = polyline((-Size_SB/2, -Size_SB/2+w0, h0) (-Size_SB/2+w0, -Size_SB/2+w0, h0))
  Polyline25 = polyline((-Size_SB/2+w0/2, -Size_SB/2+w0, h0) (-Size_SB/2+w0/2, -Size_SB/2+s0+w1, h0))
  Polyline26.sweep_along_path(Polyline25)
  Polyline27 = polyline((-Size_SB/2+w0, -Size_SB/2+w0, h0) (-Size_SB/2+w0, -Size_SB/2+w0, h0+thick1))
  Polyline26.sweep_along_path(Polyline27)
  Polyline29 [copper] = polyline((Size_SB/2-w0, -Size_SB/2+left_bottom, h0) (Size_SB/2, -Size_SB/2+left_bottom, h0))
  Polyline28 = polyline((Size_SB/2-w0/2, -Size_SB/2, h0) (Size_SB/2-w0/2, -Size_SB/2+left_bottom, h0))
  Polyline29.sweep_along_path(Polyline28)
  Polyline30 = polyline((Size_SB/2-w0/2, -Size_SB/2+left_bottom, h0) (Size_SB/2-w0/2, -Size_SB/2+left_bottom, h0+thick1))
  Polyline29.sweep_along_path(Polyline30)
  [Box1, Polyline4, Polyline6, Polyline18, Circle2, Polyline4_1, Polyline18_1, Circle2_1, Polyline23, Polyline6_1, Circle2_2, Polyline18_2, Polyline23_1, Circle2_1_1, Polyline18_1_1, Polyline26, Polyline29].mirror(point=(0mm, 0mm, 0.254mm), normal=(1mm, 1mm, 0mm))
  [Box1, Polyline4, Polyline6, Polyline18, Circle2, Polyline4_1, Polyline18_1, Circle2_1, Polyline23, Polyline6_1, Circle2_2, Polyline18_2, Polyline23_1, Circle2_1_1, Polyline18_1_1, Polyline26, Polyline29].rotate(axis=Z, angle=180deg)

design Figure_Combined (HFSS, DrivenTerminal, model units mm)
variables:
  Size_SB = 4.3mm
  h0 = 0.254mm
  l2 = 1.18mm
  l3 = 0.96mm
  l1 = 1.28mm
  r0 = 1.02mm
  w1 = 0.12mm
  s1 = 0.2mm
  s3 = 0.26mm
  x0 = 0.83mm
  y0 = 0.83mm
  thick1 = 0.026mm
  w0 = 0.06mm
  d1 = 0.2mm
  r1 = 0.2mm
  s0 = 0.3mm
  left_bottom = 0.2mm
geometry:
  Box1 [Rogers RT/duroid 5880 (tm)] = box(corner=(-Size_SB/2, -Size_SB/2, 0mm), size=(Size_SB, Size_SB, h0))
  Polyline4 [copper] = polyline((x0, -y0, h0) (x0+w1, -y0, h0))
  Polyline3 = polyline(z=h0, xy: (x0, -y0) (x0, -y0+r0+s3+w1) (x0+l3, -y0+r0+s3+w1) (x0+l3, -y0+r0+s3+w1+s1) (x0+l3-l2, -y0+r0+s3+w1+s1) (x0+l3-l2, -y0+r0+s3+w1+s1+2*w1+s1) (x0+l3, -y0+r0+s3+w1+s1+2*w1+s1) (x0+l3, -y0+r0+s3+w1+s1+2*w1+2*s1) (x0+l3-l1, -y0+r0+s3+w1+s1+2*w1+2*s1) (x0+l3-l1, -y0+r0+s3+w1+s1+4*w1+3*s1) (Size_SB/2-w0, -y0+r0+s3+w1+s1+4*w1+3*s1))
  Polyline4.sweep_along_path(Polyline3)
  Top_Red = circle(normal=Z, centre=(x0, -y0, h0), radius=r0)
  Polyline4.unite(Top_Red)
  Polyline12 = polyline((0.83mm, 0.45mm, 0.254mm) (0.83mm, 0.45mm, h0+thick1))
  Polyline4.sweep_along_path(Polyline12)
  Polyline4_1 [copper] = Polyline4.duplicate_around_axis(axis=Z, angle=180deg, total=2)
  Polyline6 [copper] = polyline((Size_SB/2-w0, -y0+r0+s3+w1+s1+3*w1+3*s1, h0) (Size_SB/2, -y0+r0+s3+w1+s1+3*w1+3*s1, h0))
  Polyline5 = polyline((Size_SB/2-w0/2, -y0+r0+s3+w1+s1+3*w1+3*s1+w1, h0) (Size_SB/2-w0/2, d1/2, h0))
  Polyline6.sweep_along_path(Polyline5)
  Polyline21 = polyline((Size_SB/2-w0/2, -y0+r0+s3+w1+s1+3*w1+3*s1, h0) (Size_SB/2-w0/2, -y0+r0+s3+w1+s1+3*w1+3*s1, h0+thick1))
  Polyline6.sweep_along_path(Polyline21)
  Polyline6_1 [copper] = Polyline6.duplicate_around_axis(axis=Z, angle=180deg, total=2)
  Polyline18 [copper] = polyline((Size_SB/2, -r1, h0) (Size_SB/2, -d1/2, h0))
  Polyline17 = polyline((Size_SB/2, -r1+(r1-d1/2)/2, h0) (2mm, 1.4936989e-17mm, 0.254mm) (2.15mm, 0.15mm, 0.254mm), AngularArc from point 0 over 3 centre=(Size_SB/2, 0mm, h0) angle=-180deg plane=XY)
  Polyline18.sweep_along_path(Polyline17)
  Polyline18.thicken(0.026mm)
  Polyline18_1 [copper] = Polyline18.duplicate_around_axis(axis=Z, angle=90deg, total=2)
  Polyline18_2 [copper] = Polyline18.duplicate_around_axis(axis=Z, angle=180deg, total=2)
  Circle2 [copper] = circle(normal=Z, centre=(Size_SB/2, 0mm, h0), radius=d1/2)
  Rectangle1 = rectangle(corner=(Size_SB/2, -d1/2, h0), x_size=d1/2, y_size=d1)
  Circle2.subtract(Rectangle1)
  Circle2.thicken(0.026mm)
  Circle2_1 [copper] = Circle2.duplicate_around_axis(axis=Z, angle=90deg, total=2)
  Circle2_2 [copper] = Circle2.duplicate_around_axis(axis=Z, angle=180deg, total=2)
  Polyline18_1_1 [copper] = Polyline18_1.duplicate_around_axis(axis=Z, angle=180deg, total=2)
  Circle2_1_1 [copper] = Circle2_1.duplicate_around_axis(axis=Z, angle=180deg, total=2)
  Polyline23 [copper] = polyline((-d1/2, Size_SB/2-w0, h0) (-d1/2, Size_SB/2, h0))
  Polyline22 = polyline((-Size_SB/2, Size_SB/2-w0/2, h0) (-d1/2, Size_SB/2-w0/2, h0))
  Polyline23.sweep_along_path(Polyline22)
  Polyline24 = polyline((-0.6125mm, 2.15mm, 0.254mm) (-0.6125mm, 2.15mm, h0 + thick1))
  Polyline23.sweep_along_path(Polyline24)
  Polyline23_1 [copper] = Polyline23.duplicate_around_axis(axis=Z, angle=180deg, total=2)
  Polyline6_1.rotate(axis=X, angle=180deg)
  Polyline6_1.rotate(axis=Y, angle=180deg)
  Polyline6_1.rotate(axis=Z, angle=180deg)
  Polyline6_1.rotate(axis=X, angle=180deg)
  Polyline6_1.move(0mm, 0mm, 2*h0+thick1)
  Circle2_2.rotate(axis=X, angle=180deg)
  Circle2_2.rotate(axis=Y, angle=180deg)
  Circle2_2.rotate(axis=Z, angle=180deg)
  Circle2_2.rotate(axis=X, angle=180deg)
  Circle2_2.move(0mm, 0mm, 2*h0+thick1)
  Polyline18_2.rotate(axis=X, angle=180deg)
  Polyline18_2.rotate(axis=Y, angle=180deg)
  Polyline18_2.rotate(axis=Z, angle=180deg)
  Polyline18_2.rotate(axis=X, angle=180deg)
  Polyline18_2.move(0mm, 0mm, 2*h0+thick1)
  Polyline23_1.rotate(axis=Y, angle=180deg)
  Polyline23_1.move(0mm, 0mm, 2*h0+thick1)
  Circle2_1_1.rotate(axis=Y, angle=180deg)
  Circle2_1_1.move(0mm, 0mm, 2*h0+thick1)
  Polyline18_1_1.rotate(axis=Y, angle=180deg)
  Polyline18_1_1.move(0mm, 0mm, 2*h0+thick1)
  Polyline26 [copper] = polyline((-Size_SB/2, -Size_SB/2+w0, h0) (-Size_SB/2+w0, -Size_SB/2+w0, h0))
  Polyline25 = polyline((-Size_SB/2+w0/2, -Size_SB/2+w0, h0) (-Size_SB/2+w0/2, -Size_SB/2+s0+w1, h0))
  Polyline26.sweep_along_path(Polyline25)
  Polyline27 = polyline((-Size_SB/2+w0, -Size_SB/2+w0, h0) (-Size_SB/2+w0, -Size_SB/2+w0, h0+thick1))
  Polyline26.sweep_along_path(Polyline27)
  Polyline29 [copper] = polyline((Size_SB/2-w0, -Size_SB/2+left_bottom, h0) (Size_SB/2, -Size_SB/2+left_bottom, h0))
  Polyline28 = polyline((Size_SB/2-w0/2, -Size_SB/2, h0) (Size_SB/2-w0/2, -Size_SB/2+left_bottom, h0))
  Polyline29.sweep_along_path(Polyline28)
  Polyline30 = polyline((Size_SB/2-w0/2, -Size_SB/2+left_bottom, h0) (Size_SB/2-w0/2, -Size_SB/2+left_bottom, h0+thick1))
  Polyline29.sweep_along_path(Polyline30)
  Polyline31 [copper] = polyline((x0, -y0, h0) (x0+w1, -y0, h0))
  Polyline37 = polyline(z=h0, xy: (x0, -y0) (x0, -y0+r0+s3+w1) (x0+l3, -y0+r0+s3+w1) (x0+l3, -y0+r0+s3+w1+s1) (x0+l3-l2, -y0+r0+s3+w1+s1) (x0+l3-l2, -y0+r0+s3+w1+s1+2*w1+s1) (x0+l3, -y0+r0+s3+w1+s1+2*w1+s1) (x0+l3, -y0+r0+s3+w1+s1+2*w1+2*s1) (x0+l3-l1, -y0+r0+s3+w1+s1+2*w1+2*s1) (x0+l3-l1, -y0+r0+s3+w1+s1+4*w1+3*s1) (Size_SB/2-w0, -y0+r0+s3+w1+s1+4*w1+3*s1))
  Polyline31.sweep_along_path(Polyline37)
  Top_Red1 = circle(normal=Z, centre=(x0, -y0, h0), radius=r0)
  Polyline31.unite(Top_Red1)
  Polyline39 = polyline((0.83mm, 0.45mm, 0.254mm) (0.83mm, 0.45mm, h0+thick1))
  Polyline31.sweep_along_path(Polyline39)
  Polyline4_2 [copper] = Polyline31.duplicate_around_axis(axis=Z, angle=180deg, total=2)
  Polyline31.mirror(point=(0mm, 0mm, 0.254mm), normal=(1mm, 1mm, 0mm))
  Polyline31.rotate(axis=Z, angle=180deg)
  Polyline31.rotate(axis=X, angle=180deg)
  Polyline31.rotate(axis=Z, angle=180deg)
  Polyline32 [copper] = polyline((Size_SB/2-w0, -y0+r0+s3+w1+s1+3*w1+3*s1, h0) (Size_SB/2, -y0+r0+s3+w1+s1+3*w1+3*s1, h0))
  Polyline38 = polyline((Size_SB/2-w0/2, -y0+r0+s3+w1+s1+3*w1+3*s1+w1, h0) (Size_SB/2-w0/2, d1/2, h0))
  Polyline32.sweep_along_path(Polyline38)
  Polyline41 = polyline((Size_SB/2-w0/2, -y0+r0+s3+w1+s1+3*w1+3*s1, h0) (Size_SB/2-w0/2, -y0+r0+s3+w1+s1+3*w1+3*s1, h0+thick1))
  Polyline32.sweep_along_path(Polyline41)
  Polyline6_2 [copper] = Polyline32.duplicate_around_axis(axis=Z, angle=180deg, total=2)
  Polyline32.mirror(point=(0mm, 0mm, 0.254mm), normal=(1mm, 1mm, 0mm))
  Polyline32.rotate(axis=Z, angle=180deg)
  Polyline32.rotate(axis=X, angle=180deg)
  Polyline32.rotate(axis=Z, angle=180deg)
  Polyline33 [copper] = polyline((Size_SB/2, -r1, h0) (Size_SB/2, -d1/2, h0))
  Polyline40 = polyline((Size_SB/2, -r1+(r1-d1/2)/2, h0) (2mm, 1.4936989e-17mm, 0.254mm) (2.15mm, 0.15mm, 0.254mm), AngularArc from point 0 over 3 centre=(Size_SB/2, 0mm, h0) angle=-180deg plane=XY)
  Polyline33.sweep_along_path(Polyline40)
  Polyline33.thicken(0.026mm)
  Polyline18_3 [copper] = Polyline33.duplicate_around_axis(axis=Z, angle=90deg, total=2)
  Polyline18_4 [copper] = Polyline33.duplicate_around_axis(axis=Z, angle=180deg, total=2)
  Polyline33.mirror(point=(0mm, 0mm, 0.254mm), normal=(1mm, 1mm, 0mm))
  Polyline33.rotate(axis=Z, angle=180deg)
  Polyline33.rotate(axis=X, angle=180deg)
  Polyline33.rotate(axis=Z, angle=180deg)
  Circle3 [copper] = circle(normal=Z, centre=(Size_SB/2, 0mm, h0), radius=d1/2)
  Rectangle2 = rectangle(corner=(Size_SB/2, -d1/2, h0), x_size=d1/2, y_size=d1)
  Circle3.subtract(Rectangle2)
  Circle3.thicken(0.026mm)
  Circle2_3 [copper] = Circle3.duplicate_around_axis(axis=Z, angle=90deg, total=2)
  Circle2_4 [copper] = Circle3.duplicate_around_axis(axis=Z, angle=180deg, total=2)
  Circle3.mirror(point=(0mm, 0mm, 0.254mm), normal=(1mm, 1mm, 0mm))
  Circle3.rotate(axis=Z, angle=180deg)
  Circle3.rotate(axis=X, angle=180deg)
  Circle3.rotate(axis=Z, angle=180deg)
  Polyline4_2.mirror(point=(0mm, 0mm, 0.254mm), normal=(1mm, 1mm, 0mm))
  Polyline4_2.rotate(axis=Z, angle=180deg)
  Polyline4_2.rotate(axis=X, angle=180deg)
  Polyline4_2.rotate(axis=Z, angle=180deg)
  Polyline18_1_2 [copper] = Polyline18_3.duplicate_around_axis(axis=Z, angle=180deg, total=2)
  Polyline18_3.mirror(point=(0mm, 0mm, 0.254mm), normal=(1mm, 1mm, 0mm))
  Polyline18_3.rotate(axis=Z, angle=180deg)
  Polyline18_3.rotate(axis=X, angle=180deg)
  Polyline18_3.rotate(axis=Z, angle=180deg)
  Circle2_1_2 [copper] = Circle2_3.duplicate_around_axis(axis=Z, angle=180deg, total=2)
  Circle2_3.mirror(point=(0mm, 0mm, 0.254mm), normal=(1mm, 1mm, 0mm))
  Circle2_3.rotate(axis=Z, angle=180deg)
  Circle2_3.rotate(axis=X, angle=180deg)
  Circle2_3.rotate(axis=Z, angle=180deg)
  Polyline34 [copper] = polyline((-d1/2, Size_SB/2-w0, h0) (-d1/2, Size_SB/2, h0))
  Polyline42 = polyline((-Size_SB/2, Size_SB/2-w0/2, h0) (-d1/2, Size_SB/2-w0/2, h0))
  Polyline34.sweep_along_path(Polyline42)
  Polyline43 = polyline((-0.6125mm, 2.15mm, 0.254mm) (-0.6125mm, 2.15mm, h0 + thick1))
  Polyline34.sweep_along_path(Polyline43)
  Polyline23_2 [copper] = Polyline34.duplicate_around_axis(axis=Z, angle=180deg, total=2)
  Polyline34.mirror(point=(0mm, 0mm, 0.254mm), normal=(1mm, 1mm, 0mm))
  Polyline34.rotate(axis=Z, angle=180deg)
  Polyline34.rotate(axis=X, angle=180deg)
  Polyline34.rotate(axis=Z, angle=180deg)
  Polyline6_2.rotate(axis=X, angle=180deg)
  Polyline6_2.rotate(axis=Y, angle=180deg)
  Polyline6_2.rotate(axis=Z, angle=180deg)
  Polyline6_2.rotate(axis=X, angle=180deg)
  Polyline6_2.move(0mm, 0mm, 2*h0+thick1)
  Polyline6_2.mirror(point=(0mm, 0mm, 0.254mm), normal=(1mm, 1mm, 0mm))
  Polyline6_2.rotate(axis=Z, angle=180deg)
  Polyline6_2.rotate(axis=X, angle=180deg)
  Polyline6_2.rotate(axis=Z, angle=180deg)
  Circle2_4.rotate(axis=X, angle=180deg)
  Circle2_4.rotate(axis=Y, angle=180deg)
  Circle2_4.rotate(axis=Z, angle=180deg)
  Circle2_4.rotate(axis=X, angle=180deg)
  Circle2_4.move(0mm, 0mm, 2*h0+thick1)
  Circle2_4.mirror(point=(0mm, 0mm, 0.254mm), normal=(1mm, 1mm, 0mm))
  Circle2_4.rotate(axis=Z, angle=180deg)
  Circle2_4.rotate(axis=X, angle=180deg)
  Circle2_4.rotate(axis=Z, angle=180deg)
  Polyline18_4.rotate(axis=X, angle=180deg)
  Polyline18_4.rotate(axis=Y, angle=180deg)
  Polyline18_4.rotate(axis=Z, angle=180deg)
  Polyline18_4.rotate(axis=X, angle=180deg)
  Polyline18_4.move(0mm, 0mm, 2*h0+thick1)
  Polyline18_4.mirror(point=(0mm, 0mm, 0.254mm), normal=(1mm, 1mm, 0mm))
  Polyline18_4.rotate(axis=Z, angle=180deg)
  Polyline18_4.rotate(axis=X, angle=180deg)
  Polyline18_4.rotate(axis=Z, angle=180deg)
  Polyline23_2.rotate(axis=Y, angle=180deg)
  Polyline23_2.move(0mm, 0mm, 2*h0+thick1)
  Polyline23_2.mirror(point=(0mm, 0mm, 0.254mm), normal=(1mm, 1mm, 0mm))
  Polyline23_2.rotate(axis=Z, angle=180deg)
  Polyline23_2.rotate(axis=X, angle=180deg)
  Polyline23_2.rotate(axis=Z, angle=180deg)
  Circle2_1_2.rotate(axis=Y, angle=180deg)
  Circle2_1_2.move(0mm, 0mm, 2*h0+thick1)
  Circle2_1_2.mirror(point=(0mm, 0mm, 0.254mm), normal=(1mm, 1mm, 0mm))
  Circle2_1_2.rotate(axis=Z, angle=180deg)
  Circle2_1_2.rotate(axis=X, angle=180deg)
  Circle2_1_2.rotate(axis=Z, angle=180deg)
  Polyline18_1_2.rotate(axis=Y, angle=180deg)
  Polyline18_1_2.move(0mm, 0mm, 2*h0+thick1)
  Polyline18_1_2.mirror(point=(0mm, 0mm, 0.254mm), normal=(1mm, 1mm, 0mm))
  Polyline18_1_2.rotate(axis=Z, angle=180deg)
  Polyline18_1_2.rotate(axis=X, angle=180deg)
  Polyline18_1_2.rotate(axis=Z, angle=180deg)
  Polyline35 [copper] = polyline((-Size_SB/2, -Size_SB/2+w0, h0) (-Size_SB/2+w0, -Size_SB/2+w0, h0))
  Polyline44 = polyline((-Size_SB/2+w0/2, -Size_SB/2+w0, h0) (-Size_SB/2+w0/2, -Size_SB/2+s0+w1, h0))
  Polyline35.sweep_along_path(Polyline44)
  Polyline45 = polyline((-Size_SB/2+w0, -Size_SB/2+w0, h0) (-Size_SB/2+w0, -Size_SB/2+w0, h0+thick1))
  Polyline35.sweep_along_path(Polyline45)
  Polyline35.mirror(point=(0mm, 0mm, 0.254mm), normal=(1mm, 1mm, 0mm))
  Polyline35.rotate(axis=Z, angle=180deg)
  Polyline35.rotate(axis=X, angle=180deg)
  Polyline35.rotate(axis=Z, angle=180deg)
  Polyline36 [copper] = polyline((Size_SB/2-w0, -Size_SB/2+left_bottom, h0) (Size_SB/2, -Size_SB/2+left_bottom, h0))
  Polyline46 = polyline((Size_SB/2-w0/2, -Size_SB/2, h0) (Size_SB/2-w0/2, -Size_SB/2+left_bottom, h0))
  Polyline36.sweep_along_path(Polyline46)
  Polyline47 = polyline((Size_SB/2-w0/2, -Size_SB/2+left_bottom, h0) (Size_SB/2-w0/2, -Size_SB/2+left_bottom, h0+thick1))
  Polyline36.sweep_along_path(Polyline47)
  Polyline36.mirror(point=(0mm, 0mm, 0.254mm), normal=(1mm, 1mm, 0mm))
  Polyline36.rotate(axis=Z, angle=180deg)
  Polyline36.rotate(axis=X, angle=180deg)
  Polyline36.rotate(axis=Z, angle=180deg)
  [Polyline31, Polyline32, Polyline33, Circle3, Polyline4_2, Polyline18_3, Circle2_3, Polyline34, Polyline6_2, Circle2_4, Polyline18_4, Polyline23_2, Circle2_1_2, Polyline18_1_2, Polyline35, Polyline36].move(0mm, 0mm, h0)

design Figure8(c)_flipped (HFSS, DrivenTerminal, model units mm)
variables:
  Size_SB = 4.3mm
  s0 = 0.3mm
  r0 = 1.02mm
  h0 = 0.254mm
  w1 = 0.12mm
  s3 = 0.26mm
  l3 = 0.96mm
  s1 = 0.2mm
  l2 = 1.18mm
  l1 = 1.28mm
  l0 = 1.52mm
  w0 = 0.06mm
  r1 = 0.2mm
  d1 = 0.2mm
  x0 = 0.83mm
  y0 = 0.83mm
  s4 = 0.3mm
  thick1 = 0.026mm
  left_bottom = 0.2mm
geometry:
  Box1 [Rogers RT/duroid 5880 (tm)] = box(corner=(-Size_SB/2, -Size_SB/2, 0mm), size=(Size_SB, Size_SB, h0))
  Box1.mirror(point=(0mm, 0mm, 0.254mm), normal=(1mm, 1mm, 0mm))
  Box1.rotate(axis=Z, angle=180deg)
  Polyline4 [copper] = polyline((x0, -y0, h0) (x0+w1, -y0, h0))
  Polyline3 = polyline(z=h0, xy: (x0, -y0) (x0, -y0+r0+s3+w1) (x0+l3, -y0+r0+s3+w1) (x0+l3, -y0+r0+s3+w1+s1) (x0+l3-l2, -y0+r0+s3+w1+s1) (x0+l3-l2, -y0+r0+s3+w1+s1+2*w1+s1) (x0+l3, -y0+r0+s3+w1+s1+2*w1+s1) (x0+l3, -y0+r0+s3+w1+s1+2*w1+2*s1) (x0+l3-l1, -y0+r0+s3+w1+s1+2*w1+2*s1) (x0+l3-l1, -y0+r0+s3+w1+s1+4*w1+3*s1) (Size_SB/2-w0, -y0+r0+s3+w1+s1+4*w1+3*s1))
  Polyline4.sweep_along_path(Polyline3)
  Top_Red = circle(normal=Z, centre=(x0, -y0, h0), radius=r0)
  Polyline4.unite(Top_Red)
  Polyline12 = polyline((0.83mm, 0.45mm, 0.254mm) (0.83mm, 0.45mm, h0+thick1))
  Polyline4.sweep_along_path(Polyline12)
  Polyline4_1 [copper] = Polyline4.duplicate_around_axis(axis=Z, angle=180deg, total=2)
  Polyline4.mirror(point=(0mm, 0mm, 0.254mm), normal=(1mm, 1mm, 0mm))
  Polyline4.rotate(axis=Z, angle=180deg)
  Polyline6 [copper] = polyline((Size_SB/2-w0, -y0+r0+s3+w1+s1+3*w1+3*s1, h0) (Size_SB/2, -y0+r0+s3+w1+s1+3*w1+3*s1, h0))
  Polyline5 = polyline((Size_SB/2-w0/2, -y0+r0+s3+w1+s1+3*w1+3*s1+w1, h0) (Size_SB/2-w0/2, d1/2, h0))
  Polyline6.sweep_along_path(Polyline5)
  Polyline21 = polyline((Size_SB/2-w0/2, -y0+r0+s3+w1+s1+3*w1+3*s1, h0) (Size_SB/2-w0/2, -y0+r0+s3+w1+s1+3*w1+3*s1, h0+thick1))
  Polyline6.sweep_along_path(Polyline21)
  Polyline6_1 [copper] = Polyline6.duplicate_around_axis(axis=Z, angle=180deg, total=2)
  Polyline6.mirror(point=(0mm, 0mm, 0.254mm), normal=(1mm, 1mm, 0mm))
  Polyline6.rotate(axis=Z, angle=180deg)
  Polyline18 [copper] = polyline((Size_SB/2, -r1, h0) (Size_SB/2, -d1/2, h0))
  Polyline17 = polyline((Size_SB/2, -r1+(r1-d1/2)/2, h0) (2mm, 1.4936989e-17mm, 0.254mm) (2.15mm, 0.15mm, 0.254mm), AngularArc from point 0 over 3 centre=(Size_SB/2, 0mm, h0) angle=-180deg plane=XY)
  Polyline18.sweep_along_path(Polyline17)
  Polyline18.thicken(0.026mm)
  Polyline18_1 [copper] = Polyline18.duplicate_around_axis(axis=Z, angle=90deg, total=2)
  Polyline18_2 [copper] = Polyline18.duplicate_around_axis(axis=Z, angle=180deg, total=2)
  Polyline18.mirror(point=(0mm, 0mm, 0.254mm), normal=(1mm, 1mm, 0mm))
  Polyline18.rotate(axis=Z, angle=180deg)
  Circle2 [copper] = circle(normal=Z, centre=(Size_SB/2, 0mm, h0), radius=d1/2)
  Rectangle1 = rectangle(corner=(Size_SB/2, -d1/2, h0), x_size=d1/2, y_size=d1)
  Circle2.subtract(Rectangle1)
  Circle2.thicken(0.026mm)
  Circle2_1 [copper] = Circle2.duplicate_around_axis(axis=Z, angle=90deg, total=2)
  Circle2_2 [copper] = Circle2.duplicate_around_axis(axis=Z, angle=180deg, total=2)
  Circle2.mirror(point=(0mm, 0mm, 0.254mm), normal=(1mm, 1mm, 0mm))
  Circle2.rotate(axis=Z, angle=180deg)
  Polyline4_1.mirror(point=(0mm, 0mm, 0.254mm), normal=(1mm, 1mm, 0mm))
  Polyline4_1.rotate(axis=Z, angle=180deg)
  Polyline18_1_1 [copper] = Polyline18_1.duplicate_around_axis(axis=Z, angle=180deg, total=2)
  Polyline18_1.mirror(point=(0mm, 0mm, 0.254mm), normal=(1mm, 1mm, 0mm))
  Polyline18_1.rotate(axis=Z, angle=180deg)
  Circle2_1_1 [copper] = Circle2_1.duplicate_around_axis(axis=Z, angle=180deg, total=2)
  Circle2_1.mirror(point=(0mm, 0mm, 0.254mm), normal=(1mm, 1mm, 0mm))
  Circle2_1.rotate(axis=Z, angle=180deg)
  Polyline23 [copper] = polyline((-d1/2, Size_SB/2-w0, h0) (-d1/2, Size_SB/2, h0))
  Polyline22 = polyline((-Size_SB/2, Size_SB/2-w0/2, h0) (-d1/2, Size_SB/2-w0/2, h0))
  Polyline23.sweep_along_path(Polyline22)
  Polyline24 = polyline((-0.6125mm, 2.15mm, 0.254mm) (-0.6125mm, 2.15mm, h0 + thick1))
  Polyline23.sweep_along_path(Polyline24)
  Polyline23_1 [copper] = Polyline23.duplicate_around_axis(axis=Z, angle=180deg, total=2)
  Polyline23.mirror(point=(0mm, 0mm, 0.254mm), normal=(1mm, 1mm, 0mm))
  Polyline23.rotate(axis=Z, angle=180deg)
  Polyline6_1.rotate(axis=X, angle=180deg)
  Polyline6_1.rotate(axis=Y, angle=180deg)
  Polyline6_1.rotate(axis=Z, angle=180deg)
  Polyline6_1.rotate(axis=X, angle=180deg)
  Polyline6_1.move(0mm, 0mm, 2*h0+thick1)
  Polyline6_1.mirror(point=(0mm, 0mm, 0.254mm), normal=(1mm, 1mm, 0mm))
  Polyline6_1.rotate(axis=Z, angle=180deg)
  Circle2_2.rotate(axis=X, angle=180deg)
  Circle2_2.rotate(axis=Y, angle=180deg)
  Circle2_2.rotate(axis=Z, angle=180deg)
  Circle2_2.rotate(axis=X, angle=180deg)
  Circle2_2.move(0mm, 0mm, 2*h0+thick1)
  Circle2_2.mirror(point=(0mm, 0mm, 0.254mm), normal=(1mm, 1mm, 0mm))
  Circle2_2.rotate(axis=Z, angle=180deg)
  Polyline18_2.rotate(axis=X, angle=180deg)
  Polyline18_2.rotate(axis=Y, angle=180deg)
  Polyline18_2.rotate(axis=Z, angle=180deg)
  Polyline18_2.rotate(axis=X, angle=180deg)
  Polyline18_2.move(0mm, 0mm, 2*h0+thick1)
  Polyline18_2.mirror(point=(0mm, 0mm, 0.254mm), normal=(1mm, 1mm, 0mm))
  Polyline18_2.rotate(axis=Z, angle=180deg)
  Polyline23_1.rotate(axis=Y, angle=180deg)
  Polyline23_1.move(0mm, 0mm, 2*h0+thick1)
  Polyline23_1.mirror(point=(0mm, 0mm, 0.254mm), normal=(1mm, 1mm, 0mm))
  Polyline23_1.rotate(axis=Z, angle=180deg)
  Circle2_1_1.rotate(axis=Y, angle=180deg)
  Circle2_1_1.move(0mm, 0mm, 2*h0+thick1)
  Circle2_1_1.mirror(point=(0mm, 0mm, 0.254mm), normal=(1mm, 1mm, 0mm))
  Circle2_1_1.rotate(axis=Z, angle=180deg)
  Polyline18_1_1.rotate(axis=Y, angle=180deg)
  Polyline18_1_1.move(0mm, 0mm, 2*h0+thick1)
  Polyline18_1_1.mirror(point=(0mm, 0mm, 0.254mm), normal=(1mm, 1mm, 0mm))
  Polyline18_1_1.rotate(axis=Z, angle=180deg)
  Polyline26 [copper] = polyline((-Size_SB/2, -Size_SB/2+w0, h0) (-Size_SB/2+w0, -Size_SB/2+w0, h0))
  Polyline25 = polyline((-Size_SB/2+w0/2, -Size_SB/2+w0, h0) (-Size_SB/2+w0/2, -Size_SB/2+s0+w1, h0))
  Polyline26.sweep_along_path(Polyline25)
  Polyline27 = polyline((-Size_SB/2+w0, -Size_SB/2+w0, h0) (-Size_SB/2+w0, -Size_SB/2+w0, h0+thick1))
  Polyline26.sweep_along_path(Polyline27)
  Polyline26.mirror(point=(0mm, 0mm, 0.254mm), normal=(1mm, 1mm, 0mm))
  Polyline26.rotate(axis=Z, angle=180deg)
  Polyline29 [copper] = polyline((Size_SB/2-w0, -Size_SB/2+left_bottom, h0) (Size_SB/2, -Size_SB/2+left_bottom, h0))
  Polyline28 = polyline((Size_SB/2-w0/2, -Size_SB/2, h0) (Size_SB/2-w0/2, -Size_SB/2+left_bottom, h0))
  Polyline29.sweep_along_path(Polyline28)
  Polyline30 = polyline((Size_SB/2-w0/2, -Size_SB/2+left_bottom, h0) (Size_SB/2-w0/2, -Size_SB/2+left_bottom, h0+thick1))
  Polyline29.sweep_along_path(Polyline30)
  Polyline29.mirror(point=(0mm, 0mm, 0.254mm), normal=(1mm, 1mm, 0mm))
  Polyline29.rotate(axis=Z, angle=180deg)
  [Box1, Polyline4, Polyline6, Polyline18, Circle2, Polyline4_1, Polyline18_1, Circle2_1, Polyline23, Polyline6_1, Circle2_2, Polyline18_2, Polyline23_1, Circle2_1_1, Polyline18_1_1, Polyline26, Polyline29].rotate(axis=X, angle=180deg)
  [Box1, Polyline4, Polyline6, Polyline18, Circle2, Polyline4_1, Polyline18_1, Circle2_1, Polyline23, Polyline6_1, Circle2_2, Polyline18_2, Polyline23_1, Circle2_1_1, Polyline18_1_1, Polyline26, Polyline29].rotate(axis=Z, angle=180deg)

design Figure8(a) (HFSS, DrivenTerminal, model units mm)
variables:
  h0 = 0.254mm
  Size_SB = 4.3mm
  s1 = 0.2mm
  l2 = 1.18mm
  l3 = 0.96mm
  thick1 = 0.026mm
  y0 = 0.83mm
  r0 = 1.02mm
  s3 = 0.26mm
  l1 = 1.28mm
  x0 = 0.83mm
  w1 = 0.12mm
  d1 = 0.2mm
  w0 = 0.06mm
  r1 = 0.2mm
  s0 = 0.3mm
  left_bottom = 0.2mm
geometry:
  Box1 [Rogers RT/duroid 5880 (tm)] = box(corner=(-Size_SB/2, -Size_SB/2, 0mm), size=(Size_SB, Size_SB, h0))
  Polyline4 [copper] = polyline((x0, -y0, h0) (x0+w1, -y0, h0))
  Polyline3 = polyline(z=h0, xy: (x0, -y0) (x0, -y0+r0+s3+w1) (x0+l3, -y0+r0+s3+w1) (x0+l3, -y0+r0+s3+w1+s1) (x0+l3-l2, -y0+r0+s3+w1+s1) (x0+l3-l2, -y0+r0+s3+w1+s1+2*w1+s1) (x0+l3, -y0+r0+s3+w1+s1+2*w1+s1) (x0+l3, -y0+r0+s3+w1+s1+2*w1+2*s1) (x0+l3-l1, -y0+r0+s3+w1+s1+2*w1+2*s1) (x0+l3-l1, -y0+r0+s3+w1+s1+4*w1+3*s1) (Size_SB/2-w0, -y0+r0+s3+w1+s1+4*w1+3*s1))
  Polyline4.sweep_along_path(Polyline3)
  Top_Red = circle(normal=Z, centre=(x0, -y0, h0), radius=r0)
  Polyline4.unite(Top_Red)
  Polyline12 = polyline((0.83mm, 0.45mm, 0.254mm) (0.83mm, 0.45mm, h0+thick1))
  Polyline4.sweep_along_path(Polyline12)
  Polyline4_1 [copper] = Polyline4.duplicate_around_axis(axis=Z, angle=180deg, total=2)
  Polyline6 [copper] = polyline((Size_SB/2-w0, -y0+r0+s3+w1+s1+3*w1+3*s1, h0) (Size_SB/2, -y0+r0+s3+w1+s1+3*w1+3*s1, h0))
  Polyline5 = polyline((Size_SB/2-w0/2, -y0+r0+s3+w1+s1+3*w1+3*s1+w1, h0) (Size_SB/2-w0/2, d1/2, h0))
  Polyline6.sweep_along_path(Polyline5)
  Polyline21 = polyline((Size_SB/2-w0/2, -y0+r0+s3+w1+s1+3*w1+3*s1, h0) (Size_SB/2-w0/2, -y0+r0+s3+w1+s1+3*w1+3*s1, h0+thick1))
  Polyline6.sweep_along_path(Polyline21)
  Polyline6_1 [copper] = Polyline6.duplicate_around_axis(axis=Z, angle=180deg, total=2)
  Polyline18 [copper] = polyline((Size_SB/2, -r1, h0) (Size_SB/2, -d1/2, h0))
  Polyline17 = polyline((Size_SB/2, -r1+(r1-d1/2)/2, h0) (2mm, 1.4936989e-17mm, 0.254mm) (2.15mm, 0.15mm, 0.254mm), AngularArc from point 0 over 3 centre=(Size_SB/2, 0mm, h0) angle=-180deg plane=XY)
  Polyline18.sweep_along_path(Polyline17)
  Polyline18.thicken(0.026mm)
  Polyline18_1 [copper] = Polyline18.duplicate_around_axis(axis=Z, angle=90deg, total=2)
  Polyline18_2 [copper] = Polyline18.duplicate_around_axis(axis=Z, angle=180deg, total=2)
  Circle2 [copper] = circle(normal=Z, centre=(Size_SB/2, 0mm, h0), radius=d1/2)
  Rectangle1 = rectangle(corner=(Size_SB/2, -d1/2, h0), x_size=d1/2, y_size=d1)
  Circle2.subtract(Rectangle1)
  Circle2.thicken(0.026mm)
  Circle2_1 [copper] = Circle2.duplicate_around_axis(axis=Z, angle=90deg, total=2)
  Circle2_2 [copper] = Circle2.duplicate_around_axis(axis=Z, angle=180deg, total=2)
  Polyline18_1_1 [copper] = Polyline18_1.duplicate_around_axis(axis=Z, angle=180deg, total=2)
  Circle2_1_1 [copper] = Circle2_1.duplicate_around_axis(axis=Z, angle=180deg, total=2)
  Polyline23 [copper] = polyline((-d1/2, Size_SB/2-w0, h0) (-d1/2, Size_SB/2, h0))
  Polyline22 = polyline((-Size_SB/2, Size_SB/2-w0/2, h0) (-d1/2, Size_SB/2-w0/2, h0))
  Polyline23.sweep_along_path(Polyline22)
  Polyline24 = polyline((-0.6125mm, 2.15mm, 0.254mm) (-0.6125mm, 2.15mm, h0 + thick1))
  Polyline23.sweep_along_path(Polyline24)
  Polyline23_1 [copper] = Polyline23.duplicate_around_axis(axis=Z, angle=180deg, total=2)
  Polyline6_1.rotate(axis=X, angle=180deg)
  Polyline6_1.rotate(axis=Y, angle=180deg)
  Polyline6_1.rotate(axis=Z, angle=180deg)
  Polyline6_1.rotate(axis=X, angle=180deg)
  Polyline6_1.move(0mm, 0mm, 2*h0+thick1)
  Circle2_2.rotate(axis=X, angle=180deg)
  Circle2_2.rotate(axis=Y, angle=180deg)
  Circle2_2.rotate(axis=Z, angle=180deg)
  Circle2_2.rotate(axis=X, angle=180deg)
  Circle2_2.move(0mm, 0mm, 2*h0+thick1)
  Polyline18_2.rotate(axis=X, angle=180deg)
  Polyline18_2.rotate(axis=Y, angle=180deg)
  Polyline18_2.rotate(axis=Z, angle=180deg)
  Polyline18_2.rotate(axis=X, angle=180deg)
  Polyline18_2.move(0mm, 0mm, 2*h0+thick1)
  Polyline23_1.rotate(axis=Y, angle=180deg)
  Polyline23_1.move(0mm, 0mm, 2*h0+thick1)
  Circle2_1_1.rotate(axis=Y, angle=180deg)
  Circle2_1_1.move(0mm, 0mm, 2*h0+thick1)
  Polyline18_1_1.rotate(axis=Y, angle=180deg)
  Polyline18_1_1.move(0mm, 0mm, 2*h0+thick1)
  Polyline26 [copper] = polyline((-Size_SB/2, -Size_SB/2+w0, h0) (-Size_SB/2+w0, -Size_SB/2+w0, h0))
  Polyline25 = polyline((-Size_SB/2+w0/2, -Size_SB/2+w0, h0) (-Size_SB/2+w0/2, -Size_SB/2+s0+w1, h0))
  Polyline26.sweep_along_path(Polyline25)
  Polyline27 = polyline((-Size_SB/2+w0, -Size_SB/2+w0, h0) (-Size_SB/2+w0, -Size_SB/2+w0, h0+thick1))
  Polyline26.sweep_along_path(Polyline27)
  Polyline29 [copper] = polyline((Size_SB/2-w0, -Size_SB/2+left_bottom, h0) (Size_SB/2, -Size_SB/2+left_bottom, h0))
  Polyline28 = polyline((Size_SB/2-w0/2, -Size_SB/2, h0) (Size_SB/2-w0/2, -Size_SB/2+left_bottom, h0))
  Polyline29.sweep_along_path(Polyline28)
  Polyline30 = polyline((Size_SB/2-w0/2, -Size_SB/2+left_bottom, h0) (Size_SB/2-w0/2, -Size_SB/2+left_bottom, h0+thick1))
  Polyline29.sweep_along_path(Polyline30)
  Polyline31 [copper] = polyline((x0, -y0, h0) (x0+w1, -y0, h0))
  Polyline37 = polyline(z=h0, xy: (x0, -y0) (x0, -y0+r0+s3+w1) (x0+l3, -y0+r0+s3+w1) (x0+l3, -y0+r0+s3+w1+s1) (x0+l3-l2, -y0+r0+s3+w1+s1) (x0+l3-l2, -y0+r0+s3+w1+s1+2*w1+s1) (x0+l3, -y0+r0+s3+w1+s1+2*w1+s1) (x0+l3, -y0+r0+s3+w1+s1+2*w1+2*s1) (x0+l3-l1, -y0+r0+s3+w1+s1+2*w1+2*s1) (x0+l3-l1, -y0+r0+s3+w1+s1+4*w1+3*s1) (Size_SB/2-w0, -y0+r0+s3+w1+s1+4*w1+3*s1))
  Polyline31.sweep_along_path(Polyline37)
  Top_Red1 = circle(normal=Z, centre=(x0, -y0, h0), radius=r0)
  Polyline31.unite(Top_Red1)
  Polyline39 = polyline((0.83mm, 0.45mm, 0.254mm) (0.83mm, 0.45mm, h0+thick1))
  Polyline31.sweep_along_path(Polyline39)
  Polyline4_2 [copper] = Polyline31.duplicate_around_axis(axis=Z, angle=180deg, total=2)
  Polyline31.mirror(point=(0mm, 0mm, 0.254mm), normal=(1mm, 1mm, 0mm))
  Polyline31.rotate(axis=Z, angle=180deg)
  Polyline31.rotate(axis=X, angle=180deg)
  Polyline31.rotate(axis=Z, angle=180deg)
  Polyline31.move(0mm, 0mm, h0)
  Polyline32 [copper] = polyline((Size_SB/2-w0, -y0+r0+s3+w1+s1+3*w1+3*s1, h0) (Size_SB/2, -y0+r0+s3+w1+s1+3*w1+3*s1, h0))
  Polyline38 = polyline((Size_SB/2-w0/2, -y0+r0+s3+w1+s1+3*w1+3*s1+w1, h0) (Size_SB/2-w0/2, d1/2, h0))
  Polyline32.sweep_along_path(Polyline38)
  Polyline41 = polyline((Size_SB/2-w0/2, -y0+r0+s3+w1+s1+3*w1+3*s1, h0) (Size_SB/2-w0/2, -y0+r0+s3+w1+s1+3*w1+3*s1, h0+thick1))
  Polyline32.sweep_along_path(Polyline41)
  Polyline6_2 [copper] = Polyline32.duplicate_around_axis(axis=Z, angle=180deg, total=2)
  Polyline32.mirror(point=(0mm, 0mm, 0.254mm), normal=(1mm, 1mm, 0mm))
  Polyline32.rotate(axis=Z, angle=180deg)
  Polyline32.rotate(axis=X, angle=180deg)
  Polyline32.rotate(axis=Z, angle=180deg)
  Polyline32.move(0mm, 0mm, h0)
  Polyline33 [copper] = polyline((Size_SB/2, -r1, h0) (Size_SB/2, -d1/2, h0))
  Polyline40 = polyline((Size_SB/2, -r1+(r1-d1/2)/2, h0) (2mm, 1.4936989e-17mm, 0.254mm) (2.15mm, 0.15mm, 0.254mm), AngularArc from point 0 over 3 centre=(Size_SB/2, 0mm, h0) angle=-180deg plane=XY)
  Polyline33.sweep_along_path(Polyline40)
  Polyline33.thicken(0.026mm)
  Polyline18_3 [copper] = Polyline33.duplicate_around_axis(axis=Z, angle=90deg, total=2)
  Polyline18_4 [copper] = Polyline33.duplicate_around_axis(axis=Z, angle=180deg, total=2)
  Polyline33.mirror(point=(0mm, 0mm, 0.254mm), normal=(1mm, 1mm, 0mm))
  Polyline33.rotate(axis=Z, angle=180deg)
  Polyline33.rotate(axis=X, angle=180deg)
  Polyline33.rotate(axis=Z, angle=180deg)
  Polyline33.move(0mm, 0mm, h0)
  Circle3 [copper] = circle(normal=Z, centre=(Size_SB/2, 0mm, h0), radius=d1/2)
  Rectangle2 = rectangle(corner=(Size_SB/2, -d1/2, h0), x_size=d1/2, y_size=d1)
  Circle3.subtract(Rectangle2)
  Circle3.thicken(0.026mm)
  Circle2_3 [copper] = Circle3.duplicate_around_axis(axis=Z, angle=90deg, total=2)
  Circle2_4 [copper] = Circle3.duplicate_around_axis(axis=Z, angle=180deg, total=2)
  Circle3.mirror(point=(0mm, 0mm, 0.254mm), normal=(1mm, 1mm, 0mm))
  Circle3.rotate(axis=Z, angle=180deg)
  Circle3.rotate(axis=X, angle=180deg)
  Circle3.rotate(axis=Z, angle=180deg)
  Circle3.move(0mm, 0mm, h0)
  Polyline4_2.mirror(point=(0mm, 0mm, 0.254mm), normal=(1mm, 1mm, 0mm))
  Polyline4_2.rotate(axis=Z, angle=180deg)
  Polyline4_2.rotate(axis=X, angle=180deg)
  Polyline4_2.rotate(axis=Z, angle=180deg)
  Polyline4_2.move(0mm, 0mm, h0)
  Polyline18_1_2 [copper] = Polyline18_3.duplicate_around_axis(axis=Z, angle=180deg, total=2)
  Polyline18_3.mirror(point=(0mm, 0mm, 0.254mm), normal=(1mm, 1mm, 0mm))
  Polyline18_3.rotate(axis=Z, angle=180deg)
  Polyline18_3.rotate(axis=X, angle=180deg)
  Polyline18_3.rotate(axis=Z, angle=180deg)
  Polyline18_3.move(0mm, 0mm, h0)
  Circle2_1_2 [copper] = Circle2_3.duplicate_around_axis(axis=Z, angle=180deg, total=2)
  Circle2_3.mirror(point=(0mm, 0mm, 0.254mm), normal=(1mm, 1mm, 0mm))
  Circle2_3.rotate(axis=Z, angle=180deg)
  Circle2_3.rotate(axis=X, angle=180deg)
  Circle2_3.rotate(axis=Z, angle=180deg)
  Circle2_3.move(0mm, 0mm, h0)
  Polyline34 [copper] = polyline((-d1/2, Size_SB/2-w0, h0) (-d1/2, Size_SB/2, h0))
  Polyline42 = polyline((-Size_SB/2, Size_SB/2-w0/2, h0) (-d1/2, Size_SB/2-w0/2, h0))
  Polyline34.sweep_along_path(Polyline42)
  Polyline43 = polyline((-0.6125mm, 2.15mm, 0.254mm) (-0.6125mm, 2.15mm, h0 + thick1))
  Polyline34.sweep_along_path(Polyline43)
  Polyline23_2 [copper] = Polyline34.duplicate_around_axis(axis=Z, angle=180deg, total=2)
  Polyline34.mirror(point=(0mm, 0mm, 0.254mm), normal=(1mm, 1mm, 0mm))
  Polyline34.rotate(axis=Z, angle=180deg)
  Polyline34.rotate(axis=X, angle=180deg)
  Polyline34.rotate(axis=Z, angle=180deg)
  Polyline34.move(0mm, 0mm, h0)
  Polyline6_2.rotate(axis=X, angle=180deg)
  Polyline6_2.rotate(axis=Y, angle=180deg)
  Polyline6_2.rotate(axis=Z, angle=180deg)
  Polyline6_2.rotate(axis=X, angle=180deg)
  Polyline6_2.move(0mm, 0mm, 2*h0+thick1)
  Polyline6_2.mirror(point=(0mm, 0mm, 0.254mm), normal=(1mm, 1mm, 0mm))
  Polyline6_2.rotate(axis=Z, angle=180deg)
  Polyline6_2.rotate(axis=X, angle=180deg)
  Polyline6_2.rotate(axis=Z, angle=180deg)
  Polyline6_2.move(0mm, 0mm, h0)
  Circle2_4.rotate(axis=X, angle=180deg)
  Circle2_4.rotate(axis=Y, angle=180deg)
  Circle2_4.rotate(axis=Z, angle=180deg)
  Circle2_4.rotate(axis=X, angle=180deg)
  Circle2_4.move(0mm, 0mm, 2*h0+thick1)
  Circle2_4.mirror(point=(0mm, 0mm, 0.254mm), normal=(1mm, 1mm, 0mm))
  Circle2_4.rotate(axis=Z, angle=180deg)
  Circle2_4.rotate(axis=X, angle=180deg)
  Circle2_4.rotate(axis=Z, angle=180deg)
  Circle2_4.move(0mm, 0mm, h0)
  Polyline18_4.rotate(axis=X, angle=180deg)
  Polyline18_4.rotate(axis=Y, angle=180deg)
  Polyline18_4.rotate(axis=Z, angle=180deg)
  Polyline18_4.rotate(axis=X, angle=180deg)
  Polyline18_4.move(0mm, 0mm, 2*h0+thick1)
  Polyline18_4.mirror(point=(0mm, 0mm, 0.254mm), normal=(1mm, 1mm, 0mm))
  Polyline18_4.rotate(axis=Z, angle=180deg)
  Polyline18_4.rotate(axis=X, angle=180deg)
  Polyline18_4.rotate(axis=Z, angle=180deg)
  Polyline18_4.move(0mm, 0mm, h0)
  Polyline23_2.rotate(axis=Y, angle=180deg)
  Polyline23_2.move(0mm, 0mm, 2*h0+thick1)
  Polyline23_2.mirror(point=(0mm, 0mm, 0.254mm), normal=(1mm, 1mm, 0mm))
  Polyline23_2.rotate(axis=Z, angle=180deg)
  Polyline23_2.rotate(axis=X, angle=180deg)
  Polyline23_2.rotate(axis=Z, angle=180deg)
  Polyline23_2.move(0mm, 0mm, h0)
  Circle2_1_2.rotate(axis=Y, angle=180deg)
  Circle2_1_2.move(0mm, 0mm, 2*h0+thick1)
  Circle2_1_2.mirror(point=(0mm, 0mm, 0.254mm), normal=(1mm, 1mm, 0mm))
  Circle2_1_2.rotate(axis=Z, angle=180deg)
  Circle2_1_2.rotate(axis=X, angle=180deg)
  Circle2_1_2.rotate(axis=Z, angle=180deg)
  Circle2_1_2.move(0mm, 0mm, h0)
  Polyline18_1_2.rotate(axis=Y, angle=180deg)
  Polyline18_1_2.move(0mm, 0mm, 2*h0+thick1)
  Polyline18_1_2.mirror(point=(0mm, 0mm, 0.254mm), normal=(1mm, 1mm, 0mm))
  Polyline18_1_2.rotate(axis=Z, angle=180deg)
  Polyline18_1_2.rotate(axis=X, angle=180deg)
  Polyline18_1_2.rotate(axis=Z, angle=180deg)
  Polyline18_1_2.move(0mm, 0mm, h0)
  Polyline35 [copper] = polyline((-Size_SB/2, -Size_SB/2+w0, h0) (-Size_SB/2+w0, -Size_SB/2+w0, h0))
  Polyline44 = polyline((-Size_SB/2+w0/2, -Size_SB/2+w0, h0) (-Size_SB/2+w0/2, -Size_SB/2+s0+w1, h0))
  Polyline35.sweep_along_path(Polyline44)
  Polyline45 = polyline((-Size_SB/2+w0, -Size_SB/2+w0, h0) (-Size_SB/2+w0, -Size_SB/2+w0, h0+thick1))
  Polyline35.sweep_along_path(Polyline45)
  Polyline35.mirror(point=(0mm, 0mm, 0.254mm), normal=(1mm, 1mm, 0mm))
  Polyline35.rotate(axis=Z, angle=180deg)
  Polyline35.rotate(axis=X, angle=180deg)
  Polyline35.rotate(axis=Z, angle=180deg)
  Polyline35.move(0mm, 0mm, h0)
  Polyline36 [copper] = polyline((Size_SB/2-w0, -Size_SB/2+left_bottom, h0) (Size_SB/2, -Size_SB/2+left_bottom, h0))
  Polyline46 = polyline((Size_SB/2-w0/2, -Size_SB/2, h0) (Size_SB/2-w0/2, -Size_SB/2+left_bottom, h0))
  Polyline36.sweep_along_path(Polyline46)
  Polyline47 = polyline((Size_SB/2-w0/2, -Size_SB/2+left_bottom, h0) (Size_SB/2-w0/2, -Size_SB/2+left_bottom, h0+thick1))
  Polyline36.sweep_along_path(Polyline47)
  Polyline36.mirror(point=(0mm, 0mm, 0.254mm), normal=(1mm, 1mm, 0mm))
  Polyline36.rotate(axis=Z, angle=180deg)
  Polyline36.rotate(axis=X, angle=180deg)
  Polyline36.rotate(axis=Z, angle=180deg)
  Polyline36.move(0mm, 0mm, h0)
  [Box1, Polyline4, Polyline6, Polyline18, Circle2, Polyline4_1, Polyline18_1, Circle2_1, Polyline23, Polyline6_1, Circle2_2, Polyline18_2, Polyline23_1, Circle2_1_1, Polyline18_1_1, Polyline26, Polyline29, Polyline31, Polyline32, Polyline33, Circle3, Polyline4_2, Polyline18_3, Circle2_3, Polyline34, Polyline6_2, Circle2_4, Polyline18_4, Polyline23_2, Circle2_1_2, Polyline18_1_2, Polyline35, Polyline36].move(-Size_SB/2, -Size_SB/2, 0mm)
  Box2 [Rogers RT/duroid 5880 (tm)] = box(corner=(-Size_SB/2, -Size_SB/2, 0mm), size=(Size_SB, Size_SB, h0))
  Polyline48 [copper] = polyline((x0, -y0, h0) (x0+w1, -y0, h0))
  Polyline60 = polyline(z=h0, xy: (x0, -y0) (x0, -y0+r0+s3+w1) (x0+l3, -y0+r0+s3+w1) (x0+l3, -y0+r0+s3+w1+s1) (x0+l3-l2, -y0+r0+s3+w1+s1) (x0+l3-l2, -y0+r0+s3+w1+s1+2*w1+s1) (x0+l3, -y0+r0+s3+w1+s1+2*w1+s1) (x0+l3, -y0+r0+s3+w1+s1+2*w1+2*s1) (x0+l3-l1, -y0+r0+s3+w1+s1+2*w1+2*s1) (x0+l3-l1, -y0+r0+s3+w1+s1+4*w1+3*s1) (Size_SB/2-w0, -y0+r0+s3+w1+s1+4*w1+3*s1))
  Polyline48.sweep_along_path(Polyline60)
  Top_Red2 = circle(normal=Z, centre=(x0, -y0, h0), radius=r0)
  Polyline48.unite(Top_Red2)
  Polyline62 = polyline((0.83mm, 0.45mm, 0.254mm) (0.83mm, 0.45mm, h0+thick1))
  Polyline48.sweep_along_path(Polyline62)
  Polyline4_3 [copper] = Polyline48.duplicate_around_axis(axis=Z, angle=180deg, total=2)
  Polyline49 [copper] = polyline((Size_SB/2-w0, -y0+r0+s3+w1+s1+3*w1+3*s1, h0) (Size_SB/2, -y0+r0+s3+w1+s1+3*w1+3*s1, h0))
  Polyline61 = polyline((Size_SB/2-w0/2, -y0+r0+s3+w1+s1+3*w1+3*s1+w1, h0) (Size_SB/2-w0/2, d1/2, h0))
  Polyline49.sweep_along_path(Polyline61)
  Polyline64 = polyline((Size_SB/2-w0/2, -y0+r0+s3+w1+s1+3*w1+3*s1, h0) (Size_SB/2-w0/2, -y0+r0+s3+w1+s1+3*w1+3*s1, h0+thick1))
  Polyline49.sweep_along_path(Polyline64)
  Polyline6_3 [copper] = Polyline49.duplicate_around_axis(axis=Z, angle=180deg, total=2)
  Polyline50 [copper] = polyline((Size_SB/2, -r1, h0) (Size_SB/2, -d1/2, h0))
  Polyline63 = polyline((Size_SB/2, -r1+(r1-d1/2)/2, h0) (2mm, 1.4936989e-17mm, 0.254mm) (2.15mm, 0.15mm, 0.254mm), AngularArc from point 0 over 3 centre=(Size_SB/2, 0mm, h0) angle=-180deg plane=XY)
  Polyline50.sweep_along_path(Polyline63)
  Polyline50.thicken(0.026mm)
  Polyline18_5 [copper] = Polyline50.duplicate_around_axis(axis=Z, angle=90deg, total=2)
  Polyline18_6 [copper] = Polyline50.duplicate_around_axis(axis=Z, angle=180deg, total=2)
  Circle4 [copper] = circle(normal=Z, centre=(Size_SB/2, 0mm, h0), radius=d1/2)
  Rectangle3 = rectangle(corner=(Size_SB/2, -d1/2, h0), x_size=d1/2, y_size=d1)
  Circle4.subtract(Rectangle3)
  Circle4.thicken(0.026mm)
  Circle2_5 [copper] = Circle4.duplicate_around_axis(axis=Z, angle=90deg, total=2)
  Circle2_6 [copper] = Circle4.duplicate_around_axis(axis=Z, angle=180deg, total=2)
  Polyline18_1_3 [copper] = Polyline18_5.duplicate_around_axis(axis=Z, angle=180deg, total=2)
  Circle2_1_3 [copper] = Circle2_5.duplicate_around_axis(axis=Z, angle=180deg, total=2)
  Polyline51 [copper] = polyline((-d1/2, Size_SB/2-w0, h0) (-d1/2, Size_SB/2, h0))
  Polyline65 = polyline((-Size_SB/2, Size_SB/2-w0/2, h0) (-d1/2, Size_SB/2-w0/2, h0))
  Polyline51.sweep_along_path(Polyline65)
  Polyline66 = polyline((-0.6125mm, 2.15mm, 0.254mm) (-0.6125mm, 2.15mm, h0 + thick1))
  Polyline51.sweep_along_path(Polyline66)
  Polyline23_3 [copper] = Polyline51.duplicate_around_axis(axis=Z, angle=180deg, total=2)
  Polyline6_3.rotate(axis=X, angle=180deg)
  Polyline6_3.rotate(axis=Y, angle=180deg)
  Polyline6_3.rotate(axis=Z, angle=180deg)
  Polyline6_3.rotate(axis=X, angle=180deg)
  Polyline6_3.move(0mm, 0mm, 2*h0+thick1)
  Circle2_6.rotate(axis=X, angle=180deg)
  Circle2_6.rotate(axis=Y, angle=180deg)
  Circle2_6.rotate(axis=Z, angle=180deg)
  Circle2_6.rotate(axis=X, angle=180deg)
  Circle2_6.move(0mm, 0mm, 2*h0+thick1)
  Polyline18_6.rotate(axis=X, angle=180deg)
  Polyline18_6.rotate(axis=Y, angle=180deg)
  Polyline18_6.rotate(axis=Z, angle=180deg)
  Polyline18_6.rotate(axis=X, angle=180deg)
  Polyline18_6.move(0mm, 0mm, 2*h0+thick1)
  Polyline23_3.rotate(axis=Y, angle=180deg)
  Polyline23_3.move(0mm, 0mm, 2*h0+thick1)
  Circle2_1_3.rotate(axis=Y, angle=180deg)
  Circle2_1_3.move(0mm, 0mm, 2*h0+thick1)
  Polyline18_1_3.rotate(axis=Y, angle=180deg)
  Polyline18_1_3.move(0mm, 0mm, 2*h0+thick1)
  Polyline52 [copper] = polyline((-Size_SB/2, -Size_SB/2+w0, h0) (-Size_SB/2+w0, -Size_SB/2+w0, h0))
  Polyline67 = polyline((-Size_SB/2+w0/2, -Size_SB/2+w0, h0) (-Size_SB/2+w0/2, -Size_SB/2+s0+w1, h0))
  Polyline52.sweep_along_path(Polyline67)
  Polyline68 = polyline((-Size_SB/2+w0, -Size_SB/2+w0, h0) (-Size_SB/2+w0, -Size_SB/2+w0, h0+thick1))
  Polyline52.sweep_along_path(Polyline68)
  Polyline53 [copper] = polyline((Size_SB/2-w0, -Size_SB/2+left_bottom, h0) (Size_SB/2, -Size_SB/2+left_bottom, h0))
  Polyline69 = polyline((Size_SB/2-w0/2, -Size_SB/2, h0) (Size_SB/2-w0/2, -Size_SB/2+left_bottom, h0))
  Polyline53.sweep_along_path(Polyline69)
  Polyline70 = polyline((Size_SB/2-w0/2, -Size_SB/2+left_bottom, h0) (Size_SB/2-w0/2, -Size_SB/2+left_bottom, h0+thick1))
  Polyline53.sweep_along_path(Polyline70)
  Polyline54 [copper] = polyline((x0, -y0, h0) (x0+w1, -y0, h0))
  Polyline71 = polyline(z=h0, xy: (x0, -y0) (x0, -y0+r0+s3+w1) (x0+l3, -y0+r0+s3+w1) (x0+l3, -y0+r0+s3+w1+s1) (x0+l3-l2, -y0+r0+s3+w1+s1) (x0+l3-l2, -y0+r0+s3+w1+s1+2*w1+s1) (x0+l3, -y0+r0+s3+w1+s1+2*w1+s1) (x0+l3, -y0+r0+s3+w1+s1+2*w1+2*s1) (x0+l3-l1, -y0+r0+s3+w1+s1+2*w1+2*s1) (x0+l3-l1, -y0+r0+s3+w1+s1+4*w1+3*s1) (Size_SB/2-w0, -y0+r0+s3+w1+s1+4*w1+3*s1))
  Polyline54.sweep_along_path(Polyline71)
  Top_Red3 = circle(normal=Z, centre=(x0, -y0, h0), radius=r0)
  Polyline54.unite(Top_Red3)
  Polyline73 = polyline((0.83mm, 0.45mm, 0.254mm) (0.83mm, 0.45mm, h0+thick1))
  Polyline54.sweep_along_path(Polyline73)
  Polyline4_4 [copper] = Polyline54.duplicate_around_axis(axis=Z, angle=180deg, total=2)
  Polyline54.mirror(point=(0mm, 0mm, 0.254mm), normal=(1mm, 1mm, 0mm))
  Polyline54.rotate(axis=Z, angle=180deg)
  Polyline54.rotate(axis=X, angle=180deg)
  Polyline54.rotate(axis=Z, angle=180deg)
  Polyline54.move(0mm, 0mm, h0)
  Polyline55 [copper] = polyline((Size_SB/2-w0, -y0+r0+s3+w1+s1+3*w1+3*s1, h0) (Size_SB/2, -y0+r0+s3+w1+s1+3*w1+3*s1, h0))
  Polyline72 = polyline((Size_SB/2-w0/2, -y0+r0+s3+w1+s1+3*w1+3*s1+w1, h0) (Size_SB/2-w0/2, d1/2, h0))
  Polyline55.sweep_along_path(Polyline72)
  Polyline75 = polyline((Size_SB/2-w0/2, -y0+r0+s3+w1+s1+3*w1+3*s1, h0) (Size_SB/2-w0/2, -y0+r0+s3+w1+s1+3*w1+3*s1, h0+thick1))
  Polyline55.sweep_along_path(Polyline75)
  Polyline6_4 [copper] = Polyline55.duplicate_around_axis(axis=Z, angle=180deg, total=2)
  Polyline55.mirror(point=(0mm, 0mm, 0.254mm), normal=(1mm, 1mm, 0mm))
  Polyline55.rotate(axis=Z, angle=180deg)
  Polyline55.rotate(axis=X, angle=180deg)
  Polyline55.rotate(axis=Z, angle=180deg)
  Polyline55.move(0mm, 0mm, h0)
  Polyline56 [copper] = polyline((Size_SB/2, -r1, h0) (Size_SB/2, -d1/2, h0))
  Polyline74 = polyline((Size_SB/2, -r1+(r1-d1/2)/2, h0) (2mm, 1.4936989e-17mm, 0.254mm) (2.15mm, 0.15mm, 0.254mm), AngularArc from point 0 over 3 centre=(Size_SB/2, 0mm, h0) angle=-180deg plane=XY)
  Polyline56.sweep_along_path(Polyline74)
  Polyline56.thicken(0.026mm)
  Polyline18_7 [copper] = Polyline56.duplicate_around_axis(axis=Z, angle=90deg, total=2)
  Polyline18_8 [copper] = Polyline56.duplicate_around_axis(axis=Z, angle=180deg, total=2)
  Polyline56.mirror(point=(0mm, 0mm, 0.254mm), normal=(1mm, 1mm, 0mm))
  Polyline56.rotate(axis=Z, angle=180deg)
  Polyline56.rotate(axis=X, angle=180deg)
  Polyline56.rotate(axis=Z, angle=180deg)
  Polyline56.move(0mm, 0mm, h0)
  Circle5 [copper] = circle(normal=Z, centre=(Size_SB/2, 0mm, h0), radius=d1/2)
  Rectangle4 = rectangle(corner=(Size_SB/2, -d1/2, h0), x_size=d1/2, y_size=d1)
  Circle5.subtract(Rectangle4)
  Circle5.thicken(0.026mm)
  Circle2_7 [copper] = Circle5.duplicate_around_axis(axis=Z, angle=90deg, total=2)
  Circle2_8 [copper] = Circle5.duplicate_around_axis(axis=Z, angle=180deg, total=2)
  Circle5.mirror(point=(0mm, 0mm, 0.254mm), normal=(1mm, 1mm, 0mm))
  Circle5.rotate(axis=Z, angle=180deg)
  Circle5.rotate(axis=X, angle=180deg)
  Circle5.rotate(axis=Z, angle=180deg)
  Circle5.move(0mm, 0mm, h0)
  Polyline4_4.mirror(point=(0mm, 0mm, 0.254mm), normal=(1mm, 1mm, 0mm))
  Polyline4_4.rotate(axis=Z, angle=180deg)
  Polyline4_4.rotate(axis=X, angle=180deg)
  Polyline4_4.rotate(axis=Z, angle=180deg)
  Polyline4_4.move(0mm, 0mm, h0)
  Polyline18_1_4 [copper] = Polyline18_7.duplicate_around_axis(axis=Z, angle=180deg, total=2)
  Polyline18_7.mirror(point=(0mm, 0mm, 0.254mm), normal=(1mm, 1mm, 0mm))
  Polyline18_7.rotate(axis=Z, angle=180deg)
  Polyline18_7.rotate(axis=X, angle=180deg)
  Polyline18_7.rotate(axis=Z, angle=180deg)
  Polyline18_7.move(0mm, 0mm, h0)
  Circle2_1_4 [copper] = Circle2_7.duplicate_around_axis(axis=Z, angle=180deg, total=2)
  Circle2_7.mirror(point=(0mm, 0mm, 0.254mm), normal=(1mm, 1mm, 0mm))
  Circle2_7.rotate(axis=Z, angle=180deg)
  Circle2_7.rotate(axis=X, angle=180deg)
  Circle2_7.rotate(axis=Z, angle=180deg)
  Circle2_7.move(0mm, 0mm, h0)
  Polyline57 [copper] = polyline((-d1/2, Size_SB/2-w0, h0) (-d1/2, Size_SB/2, h0))
  Polyline76 = polyline((-Size_SB/2, Size_SB/2-w0/2, h0) (-d1/2, Size_SB/2-w0/2, h0))
  Polyline57.sweep_along_path(Polyline76)
  Polyline77 = polyline((-0.6125mm, 2.15mm, 0.254mm) (-0.6125mm, 2.15mm, h0 + thick1))
  Polyline57.sweep_along_path(Polyline77)
  Polyline23_4 [copper] = Polyline57.duplicate_around_axis(axis=Z, angle=180deg, total=2)
  Polyline57.mirror(point=(0mm, 0mm, 0.254mm), normal=(1mm, 1mm, 0mm))
  Polyline57.rotate(axis=Z, angle=180deg)
  Polyline57.rotate(axis=X, angle=180deg)
  Polyline57.rotate(axis=Z, angle=180deg)
  Polyline57.move(0mm, 0mm, h0)
  Polyline6_4.rotate(axis=X, angle=180deg)
  Polyline6_4.rotate(axis=Y, angle=180deg)
  Polyline6_4.rotate(axis=Z, angle=180deg)
  Polyline6_4.rotate(axis=X, angle=180deg)
  Polyline6_4.move(0mm, 0mm, 2*h0+thick1)
  Polyline6_4.mirror(point=(0mm, 0mm, 0.254mm), normal=(1mm, 1mm, 0mm))
  Polyline6_4.rotate(axis=Z, angle=180deg)
  Polyline6_4.rotate(axis=X, angle=180deg)
  Polyline6_4.rotate(axis=Z, angle=180deg)
  Polyline6_4.move(0mm, 0mm, h0)
  Circle2_8.rotate(axis=X, angle=180deg)
  Circle2_8.rotate(axis=Y, angle=180deg)
  Circle2_8.rotate(axis=Z, angle=180deg)
  Circle2_8.rotate(axis=X, angle=180deg)
  Circle2_8.move(0mm, 0mm, 2*h0+thick1)
  Circle2_8.mirror(point=(0mm, 0mm, 0.254mm), normal=(1mm, 1mm, 0mm))
  Circle2_8.rotate(axis=Z, angle=180deg)
  Circle2_8.rotate(axis=X, angle=180deg)
  Circle2_8.rotate(axis=Z, angle=180deg)
  Circle2_8.move(0mm, 0mm, h0)
  Polyline18_8.rotate(axis=X, angle=180deg)
  Polyline18_8.rotate(axis=Y, angle=180deg)
  Polyline18_8.rotate(axis=Z, angle=180deg)
  Polyline18_8.rotate(axis=X, angle=180deg)
  Polyline18_8.move(0mm, 0mm, 2*h0+thick1)
  Polyline18_8.mirror(point=(0mm, 0mm, 0.254mm), normal=(1mm, 1mm, 0mm))
  Polyline18_8.rotate(axis=Z, angle=180deg)
  Polyline18_8.rotate(axis=X, angle=180deg)
  Polyline18_8.rotate(axis=Z, angle=180deg)
  Polyline18_8.move(0mm, 0mm, h0)
  Polyline23_4.rotate(axis=Y, angle=180deg)
  Polyline23_4.move(0mm, 0mm, 2*h0+thick1)
  Polyline23_4.mirror(point=(0mm, 0mm, 0.254mm), normal=(1mm, 1mm, 0mm))
  Polyline23_4.rotate(axis=Z, angle=180deg)
  Polyline23_4.rotate(axis=X, angle=180deg)
  Polyline23_4.rotate(axis=Z, angle=180deg)
  Polyline23_4.move(0mm, 0mm, h0)
  Circle2_1_4.rotate(axis=Y, angle=180deg)
  Circle2_1_4.move(0mm, 0mm, 2*h0+thick1)
  Circle2_1_4.mirror(point=(0mm, 0mm, 0.254mm), normal=(1mm, 1mm, 0mm))
  Circle2_1_4.rotate(axis=Z, angle=180deg)
  Circle2_1_4.rotate(axis=X, angle=180deg)
  Circle2_1_4.rotate(axis=Z, angle=180deg)
  Circle2_1_4.move(0mm, 0mm, h0)
  Polyline18_1_4.rotate(axis=Y, angle=180deg)
  Polyline18_1_4.move(0mm, 0mm, 2*h0+thick1)
  Polyline18_1_4.mirror(point=(0mm, 0mm, 0.254mm), normal=(1mm, 1mm, 0mm))
  Polyline18_1_4.rotate(axis=Z, angle=180deg)
  Polyline18_1_4.rotate(axis=X, angle=180deg)
  Polyline18_1_4.rotate(axis=Z, angle=180deg)
  Polyline18_1_4.move(0mm, 0mm, h0)
  Polyline58 [copper] = polyline((-Size_SB/2, -Size_SB/2+w0, h0) (-Size_SB/2+w0, -Size_SB/2+w0, h0))
  Polyline78 = polyline((-Size_SB/2+w0/2, -Size_SB/2+w0, h0) (-Size_SB/2+w0/2, -Size_SB/2+s0+w1, h0))
  Polyline58.sweep_along_path(Polyline78)
  Polyline79 = polyline((-Size_SB/2+w0, -Size_SB/2+w0, h0) (-Size_SB/2+w0, -Size_SB/2+w0, h0+thick1))
  Polyline58.sweep_along_path(Polyline79)
  Polyline58.mirror(point=(0mm, 0mm, 0.254mm), normal=(1mm, 1mm, 0mm))
  Polyline58.rotate(axis=Z, angle=180deg)
  Polyline58.rotate(axis=X, angle=180deg)
  Polyline58.rotate(axis=Z, angle=180deg)
  Polyline58.move(0mm, 0mm, h0)
  Polyline59 [copper] = polyline((Size_SB/2-w0, -Size_SB/2+left_bottom, h0) (Size_SB/2, -Size_SB/2+left_bottom, h0))
  Polyline80 = polyline((Size_SB/2-w0/2, -Size_SB/2, h0) (Size_SB/2-w0/2, -Size_SB/2+left_bottom, h0))
  Polyline59.sweep_along_path(Polyline80)
  Polyline81 = polyline((Size_SB/2-w0/2, -Size_SB/2+left_bottom, h0) (Size_SB/2-w0/2, -Size_SB/2+left_bottom, h0+thick1))
  Polyline59.sweep_along_path(Polyline81)
  Polyline59.mirror(point=(0mm, 0mm, 0.254mm), normal=(1mm, 1mm, 0mm))
  Polyline59.rotate(axis=Z, angle=180deg)
  Polyline59.rotate(axis=X, angle=180deg)
  Polyline59.rotate(axis=Z, angle=180deg)
  Polyline59.move(0mm, 0mm, h0)
  [Box2, Polyline48, Polyline49, Polyline50, Circle4, Polyline4_3, Polyline18_5, Circle2_5, Polyline51, Polyline6_3, Circle2_6, Polyline18_6, Polyline23_3, Circle2_1_3, Polyline18_1_3, Polyline52..Polyline56, Circle5, Polyline4_4, Polyline18_7, Circle2_7, Polyline57, Polyline6_4, Circle2_8, Polyline18_8, Polyline23_4, Circle2_1_4, Polyline18_1_4, Polyline58, Polyline59].move(-Size_SB/2, Size_SB/2, 0mm)
  Box3 [Rogers RT/duroid 5880 (tm)] = box(corner=(-Size_SB/2, -Size_SB/2, 0mm), size=(Size_SB, Size_SB, h0))
  Polyline82 [copper] = polyline((x0, -y0, h0) (x0+w1, -y0, h0))
  Polyline94 = polyline(z=h0, xy: (x0, -y0) (x0, -y0+r0+s3+w1) (x0+l3, -y0+r0+s3+w1) (x0+l3, -y0+r0+s3+w1+s1) (x0+l3-l2, -y0+r0+s3+w1+s1) (x0+l3-l2, -y0+r0+s3+w1+s1+2*w1+s1) (x0+l3, -y0+r0+s3+w1+s1+2*w1+s1) (x0+l3, -y0+r0+s3+w1+s1+2*w1+2*s1) (x0+l3-l1, -y0+r0+s3+w1+s1+2*w1+2*s1) (x0+l3-l1, -y0+r0+s3+w1+s1+4*w1+3*s1) (Size_SB/2-w0, -y0+r0+s3+w1+s1+4*w1+3*s1))
  Polyline82.sweep_along_path(Polyline94)
  Top_Red4 = circle(normal=Z, centre=(x0, -y0, h0), radius=r0)
  Polyline82.unite(Top_Red4)
  Polyline96 = polyline((0.83mm, 0.45mm, 0.254mm) (0.83mm, 0.45mm, h0+thick1))
  Polyline82.sweep_along_path(Polyline96)
  Polyline4_5 [copper] = Polyline82.duplicate_around_axis(axis=Z, angle=180deg, total=2)
  Polyline83 [copper] = polyline((Size_SB/2-w0, -y0+r0+s3+w1+s1+3*w1+3*s1, h0) (Size_SB/2, -y0+r0+s3+w1+s1+3*w1+3*s1, h0))
  Polyline95 = polyline((Size_SB/2-w0/2, -y0+r0+s3+w1+s1+3*w1+3*s1+w1, h0) (Size_SB/2-w0/2, d1/2, h0))
  Polyline83.sweep_along_path(Polyline95)
  Polyline98 = polyline((Size_SB/2-w0/2, -y0+r0+s3+w1+s1+3*w1+3*s1, h0) (Size_SB/2-w0/2, -y0+r0+s3+w1+s1+3*w1+3*s1, h0+thick1))
  Polyline83.sweep_along_path(Polyline98)
  Polyline6_5 [copper] = Polyline83.duplicate_around_axis(axis=Z, angle=180deg, total=2)
  Polyline84 [copper] = polyline((Size_SB/2, -r1, h0) (Size_SB/2, -d1/2, h0))
  Polyline97 = polyline((Size_SB/2, -r1+(r1-d1/2)/2, h0) (2mm, 1.4936989e-17mm, 0.254mm) (2.15mm, 0.15mm, 0.254mm), AngularArc from point 0 over 3 centre=(Size_SB/2, 0mm, h0) angle=-180deg plane=XY)
  Polyline84.sweep_along_path(Polyline97)
  Polyline84.thicken(0.026mm)
  Polyline18_9 [copper] = Polyline84.duplicate_around_axis(axis=Z, angle=90deg, total=2)
  Polyline18_10 [copper] = Polyline84.duplicate_around_axis(axis=Z, angle=180deg, total=2)
  Circle6 [copper] = circle(normal=Z, centre=(Size_SB/2, 0mm, h0), radius=d1/2)
  Rectangle5 = rectangle(corner=(Size_SB/2, -d1/2, h0), x_size=d1/2, y_size=d1)
  Circle6.subtract(Rectangle5)
  Circle6.thicken(0.026mm)
  Circle2_9 [copper] = Circle6.duplicate_around_axis(axis=Z, angle=90deg, total=2)
  Circle2_10 [copper] = Circle6.duplicate_around_axis(axis=Z, angle=180deg, total=2)
  Polyline18_1_5 [copper] = Polyline18_9.duplicate_around_axis(axis=Z, angle=180deg, total=2)
  Circle2_1_5 [copper] = Circle2_9.duplicate_around_axis(axis=Z, angle=180deg, total=2)
  Polyline85 [copper] = polyline((-d1/2, Size_SB/2-w0, h0) (-d1/2, Size_SB/2, h0))
  Polyline99 = polyline((-Size_SB/2, Size_SB/2-w0/2, h0) (-d1/2, Size_SB/2-w0/2, h0))
  Polyline85.sweep_along_path(Polyline99)
  Polyline100 = polyline((-0.6125mm, 2.15mm, 0.254mm) (-0.6125mm, 2.15mm, h0 + thick1))
  Polyline85.sweep_along_path(Polyline100)
  Polyline23_5 [copper] = Polyline85.duplicate_around_axis(axis=Z, angle=180deg, total=2)
  Polyline6_5.rotate(axis=X, angle=180deg)
  Polyline6_5.rotate(axis=Y, angle=180deg)
  Polyline6_5.rotate(axis=Z, angle=180deg)
  Polyline6_5.rotate(axis=X, angle=180deg)
  Polyline6_5.move(0mm, 0mm, 2*h0+thick1)
  Circle2_10.rotate(axis=X, angle=180deg)
  Circle2_10.rotate(axis=Y, angle=180deg)
  Circle2_10.rotate(axis=Z, angle=180deg)
  Circle2_10.rotate(axis=X, angle=180deg)
  Circle2_10.move(0mm, 0mm, 2*h0+thick1)
  Polyline18_10.rotate(axis=X, angle=180deg)
  Polyline18_10.rotate(axis=Y, angle=180deg)
  Polyline18_10.rotate(axis=Z, angle=180deg)
  Polyline18_10.rotate(axis=X, angle=180deg)
  Polyline18_10.move(0mm, 0mm, 2*h0+thick1)
  Polyline23_5.rotate(axis=Y, angle=180deg)
  Polyline23_5.move(0mm, 0mm, 2*h0+thick1)
  Circle2_1_5.rotate(axis=Y, angle=180deg)
  Circle2_1_5.move(0mm, 0mm, 2*h0+thick1)
  Polyline18_1_5.rotate(axis=Y, angle=180deg)
  Polyline18_1_5.move(0mm, 0mm, 2*h0+thick1)
  Polyline86 [copper] = polyline((-Size_SB/2, -Size_SB/2+w0, h0) (-Size_SB/2+w0, -Size_SB/2+w0, h0))
  Polyline101 = polyline((-Size_SB/2+w0/2, -Size_SB/2+w0, h0) (-Size_SB/2+w0/2, -Size_SB/2+s0+w1, h0))
  Polyline86.sweep_along_path(Polyline101)
  Polyline102 = polyline((-Size_SB/2+w0, -Size_SB/2+w0, h0) (-Size_SB/2+w0, -Size_SB/2+w0, h0+thick1))
  Polyline86.sweep_along_path(Polyline102)
  Polyline87 [copper] = polyline((Size_SB/2-w0, -Size_SB/2+left_bottom, h0) (Size_SB/2, -Size_SB/2+left_bottom, h0))
  Polyline103 = polyline((Size_SB/2-w0/2, -Size_SB/2, h0) (Size_SB/2-w0/2, -Size_SB/2+left_bottom, h0))
  Polyline87.sweep_along_path(Polyline103)
  Polyline104 = polyline((Size_SB/2-w0/2, -Size_SB/2+left_bottom, h0) (Size_SB/2-w0/2, -Size_SB/2+left_bottom, h0+thick1))
  Polyline87.sweep_along_path(Polyline104)
  Polyline88 [copper] = polyline((x0, -y0, h0) (x0+w1, -y0, h0))
  Polyline105 = polyline(z=h0, xy: (x0, -y0) (x0, -y0+r0+s3+w1) (x0+l3, -y0+r0+s3+w1) (x0+l3, -y0+r0+s3+w1+s1) (x0+l3-l2, -y0+r0+s3+w1+s1) (x0+l3-l2, -y0+r0+s3+w1+s1+2*w1+s1) (x0+l3, -y0+r0+s3+w1+s1+2*w1+s1) (x0+l3, -y0+r0+s3+w1+s1+2*w1+2*s1) (x0+l3-l1, -y0+r0+s3+w1+s1+2*w1+2*s1) (x0+l3-l1, -y0+r0+s3+w1+s1+4*w1+3*s1) (Size_SB/2-w0, -y0+r0+s3+w1+s1+4*w1+3*s1))
  Polyline88.sweep_along_path(Polyline105)
  Top_Red5 = circle(normal=Z, centre=(x0, -y0, h0), radius=r0)
  Polyline88.unite(Top_Red5)
  Polyline107 = polyline((0.83mm, 0.45mm, 0.254mm) (0.83mm, 0.45mm, h0+thick1))
  Polyline88.sweep_along_path(Polyline107)
  Polyline4_6 [copper] = Polyline88.duplicate_around_axis(axis=Z, angle=180deg, total=2)
  Polyline88.mirror(point=(0mm, 0mm, 0.254mm), normal=(1mm, 1mm, 0mm))
  Polyline88.rotate(axis=Z, angle=180deg)
  Polyline88.rotate(axis=X, angle=180deg)
  Polyline88.rotate(axis=Z, angle=180deg)
  Polyline88.move(0mm, 0mm, h0)
  Polyline89 [copper] = polyline((Size_SB/2-w0, -y0+r0+s3+w1+s1+3*w1+3*s1, h0) (Size_SB/2, -y0+r0+s3+w1+s1+3*w1+3*s1, h0))
  Polyline106 = polyline((Size_SB/2-w0/2, -y0+r0+s3+w1+s1+3*w1+3*s1+w1, h0) (Size_SB/2-w0/2, d1/2, h0))
  Polyline89.sweep_along_path(Polyline106)
  Polyline109 = polyline((Size_SB/2-w0/2, -y0+r0+s3+w1+s1+3*w1+3*s1, h0) (Size_SB/2-w0/2, -y0+r0+s3+w1+s1+3*w1+3*s1, h0+thick1))
  Polyline89.sweep_along_path(Polyline109)
  Polyline6_6 [copper] = Polyline89.duplicate_around_axis(axis=Z, angle=180deg, total=2)
  Polyline89.mirror(point=(0mm, 0mm, 0.254mm), normal=(1mm, 1mm, 0mm))
  Polyline89.rotate(axis=Z, angle=180deg)
  Polyline89.rotate(axis=X, angle=180deg)
  Polyline89.rotate(axis=Z, angle=180deg)
  Polyline89.move(0mm, 0mm, h0)
  Polyline90 [copper] = polyline((Size_SB/2, -r1, h0) (Size_SB/2, -d1/2, h0))
  Polyline108 = polyline((Size_SB/2, -r1+(r1-d1/2)/2, h0) (2mm, 1.4936989e-17mm, 0.254mm) (2.15mm, 0.15mm, 0.254mm), AngularArc from point 0 over 3 centre=(Size_SB/2, 0mm, h0) angle=-180deg plane=XY)
  Polyline90.sweep_along_path(Polyline108)
  Polyline90.thicken(0.026mm)
  Polyline18_11 [copper] = Polyline90.duplicate_around_axis(axis=Z, angle=90deg, total=2)
  Polyline18_12 [copper] = Polyline90.duplicate_around_axis(axis=Z, angle=180deg, total=2)
  Polyline90.mirror(point=(0mm, 0mm, 0.254mm), normal=(1mm, 1mm, 0mm))
  Polyline90.rotate(axis=Z, angle=180deg)
  Polyline90.rotate(axis=X, angle=180deg)
  Polyline90.rotate(axis=Z, angle=180deg)
  Polyline90.move(0mm, 0mm, h0)
  Circle7 [copper] = circle(normal=Z, centre=(Size_SB/2, 0mm, h0), radius=d1/2)
  Rectangle6 = rectangle(corner=(Size_SB/2, -d1/2, h0), x_size=d1/2, y_size=d1)
  Circle7.subtract(Rectangle6)
  Circle7.thicken(0.026mm)
  Circle2_11 [copper] = Circle7.duplicate_around_axis(axis=Z, angle=90deg, total=2)
  Circle2_12 [copper] = Circle7.duplicate_around_axis(axis=Z, angle=180deg, total=2)
  Circle7.mirror(point=(0mm, 0mm, 0.254mm), normal=(1mm, 1mm, 0mm))
  Circle7.rotate(axis=Z, angle=180deg)
  Circle7.rotate(axis=X, angle=180deg)
  Circle7.rotate(axis=Z, angle=180deg)
  Circle7.move(0mm, 0mm, h0)
  Polyline4_6.mirror(point=(0mm, 0mm, 0.254mm), normal=(1mm, 1mm, 0mm))
  Polyline4_6.rotate(axis=Z, angle=180deg)
  Polyline4_6.rotate(axis=X, angle=180deg)
  Polyline4_6.rotate(axis=Z, angle=180deg)
  Polyline4_6.move(0mm, 0mm, h0)
  Polyline18_1_6 [copper] = Polyline18_11.duplicate_around_axis(axis=Z, angle=180deg, total=2)
  Polyline18_11.mirror(point=(0mm, 0mm, 0.254mm), normal=(1mm, 1mm, 0mm))
  Polyline18_11.rotate(axis=Z, angle=180deg)
  Polyline18_11.rotate(axis=X, angle=180deg)
  Polyline18_11.rotate(axis=Z, angle=180deg)
  Polyline18_11.move(0mm, 0mm, h0)
  Circle2_1_6 [copper] = Circle2_11.duplicate_around_axis(axis=Z, angle=180deg, total=2)
  Circle2_11.mirror(point=(0mm, 0mm, 0.254mm), normal=(1mm, 1mm, 0mm))
  Circle2_11.rotate(axis=Z, angle=180deg)
  Circle2_11.rotate(axis=X, angle=180deg)
  Circle2_11.rotate(axis=Z, angle=180deg)
  Circle2_11.move(0mm, 0mm, h0)
  Polyline91 [copper] = polyline((-d1/2, Size_SB/2-w0, h0) (-d1/2, Size_SB/2, h0))
  Polyline110 = polyline((-Size_SB/2, Size_SB/2-w0/2, h0) (-d1/2, Size_SB/2-w0/2, h0))
  Polyline91.sweep_along_path(Polyline110)
  Polyline111 = polyline((-0.6125mm, 2.15mm, 0.254mm) (-0.6125mm, 2.15mm, h0 + thick1))
  Polyline91.sweep_along_path(Polyline111)
  Polyline23_6 [copper] = Polyline91.duplicate_around_axis(axis=Z, angle=180deg, total=2)
  Polyline91.mirror(point=(0mm, 0mm, 0.254mm), normal=(1mm, 1mm, 0mm))
  Polyline91.rotate(axis=Z, angle=180deg)
  Polyline91.rotate(axis=X, angle=180deg)
  Polyline91.rotate(axis=Z, angle=180deg)
  Polyline91.move(0mm, 0mm, h0)
  Polyline6_6.rotate(axis=X, angle=180deg)
  Polyline6_6.rotate(axis=Y, angle=180deg)
  Polyline6_6.rotate(axis=Z, angle=180deg)
  Polyline6_6.rotate(axis=X, angle=180deg)
  Polyline6_6.move(0mm, 0mm, 2*h0+thick1)
  Polyline6_6.mirror(point=(0mm, 0mm, 0.254mm), normal=(1mm, 1mm, 0mm))
  Polyline6_6.rotate(axis=Z, angle=180deg)
  Polyline6_6.rotate(axis=X, angle=180deg)
  Polyline6_6.rotate(axis=Z, angle=180deg)
  Polyline6_6.move(0mm, 0mm, h0)
  Circle2_12.rotate(axis=X, angle=180deg)
  Circle2_12.rotate(axis=Y, angle=180deg)
  Circle2_12.rotate(axis=Z, angle=180deg)
  Circle2_12.rotate(axis=X, angle=180deg)
  Circle2_12.move(0mm, 0mm, 2*h0+thick1)
  Circle2_12.mirror(point=(0mm, 0mm, 0.254mm), normal=(1mm, 1mm, 0mm))
  Circle2_12.rotate(axis=Z, angle=180deg)
  Circle2_12.rotate(axis=X, angle=180deg)
  Circle2_12.rotate(axis=Z, angle=180deg)
  Circle2_12.move(0mm, 0mm, h0)
  Polyline18_12.rotate(axis=X, angle=180deg)
  Polyline18_12.rotate(axis=Y, angle=180deg)
  Polyline18_12.rotate(axis=Z, angle=180deg)
  Polyline18_12.rotate(axis=X, angle=180deg)
  Polyline18_12.move(0mm, 0mm, 2*h0+thick1)
  Polyline18_12.mirror(point=(0mm, 0mm, 0.254mm), normal=(1mm, 1mm, 0mm))
  Polyline18_12.rotate(axis=Z, angle=180deg)
  Polyline18_12.rotate(axis=X, angle=180deg)
  Polyline18_12.rotate(axis=Z, angle=180deg)
  Polyline18_12.move(0mm, 0mm, h0)
  Polyline23_6.rotate(axis=Y, angle=180deg)
  Polyline23_6.move(0mm, 0mm, 2*h0+thick1)
  Polyline23_6.mirror(point=(0mm, 0mm, 0.254mm), normal=(1mm, 1mm, 0mm))
  Polyline23_6.rotate(axis=Z, angle=180deg)
  Polyline23_6.rotate(axis=X, angle=180deg)
  Polyline23_6.rotate(axis=Z, angle=180deg)
  Polyline23_6.move(0mm, 0mm, h0)
  Circle2_1_6.rotate(axis=Y, angle=180deg)
  Circle2_1_6.move(0mm, 0mm, 2*h0+thick1)
  Circle2_1_6.mirror(point=(0mm, 0mm, 0.254mm), normal=(1mm, 1mm, 0mm))
  Circle2_1_6.rotate(axis=Z, angle=180deg)
  Circle2_1_6.rotate(axis=X, angle=180deg)
  Circle2_1_6.rotate(axis=Z, angle=180deg)
  Circle2_1_6.move(0mm, 0mm, h0)
  Polyline18_1_6.rotate(axis=Y, angle=180deg)
  Polyline18_1_6.move(0mm, 0mm, 2*h0+thick1)
  Polyline18_1_6.mirror(point=(0mm, 0mm, 0.254mm), normal=(1mm, 1mm, 0mm))
  Polyline18_1_6.rotate(axis=Z, angle=180deg)
  Polyline18_1_6.rotate(axis=X, angle=180deg)
  Polyline18_1_6.rotate(axis=Z, angle=180deg)
  Polyline18_1_6.move(0mm, 0mm, h0)
  Polyline92 [copper] = polyline((-Size_SB/2, -Size_SB/2+w0, h0) (-Size_SB/2+w0, -Size_SB/2+w0, h0))
  Polyline112 = polyline((-Size_SB/2+w0/2, -Size_SB/2+w0, h0) (-Size_SB/2+w0/2, -Size_SB/2+s0+w1, h0))
  Polyline92.sweep_along_path(Polyline112)
  Polyline113 = polyline((-Size_SB/2+w0, -Size_SB/2+w0, h0) (-Size_SB/2+w0, -Size_SB/2+w0, h0+thick1))
  Polyline92.sweep_along_path(Polyline113)
  Polyline92.mirror(point=(0mm, 0mm, 0.254mm), normal=(1mm, 1mm, 0mm))
  Polyline92.rotate(axis=Z, angle=180deg)
  Polyline92.rotate(axis=X, angle=180deg)
  Polyline92.rotate(axis=Z, angle=180deg)
  Polyline92.move(0mm, 0mm, h0)
  Polyline93 [copper] = polyline((Size_SB/2-w0, -Size_SB/2+left_bottom, h0) (Size_SB/2, -Size_SB/2+left_bottom, h0))
  Polyline114 = polyline((Size_SB/2-w0/2, -Size_SB/2, h0) (Size_SB/2-w0/2, -Size_SB/2+left_bottom, h0))
  Polyline93.sweep_along_path(Polyline114)
  Polyline115 = polyline((Size_SB/2-w0/2, -Size_SB/2+left_bottom, h0) (Size_SB/2-w0/2, -Size_SB/2+left_bottom, h0+thick1))
  Polyline93.sweep_along_path(Polyline115)
  Polyline93.mirror(point=(0mm, 0mm, 0.254mm), normal=(1mm, 1mm, 0mm))
  Polyline93.rotate(axis=Z, angle=180deg)
  Polyline93.rotate(axis=X, angle=180deg)
  Polyline93.rotate(axis=Z, angle=180deg)
  Polyline93.move(0mm, 0mm, h0)
  [Box3, Polyline82, Polyline83, Polyline84, Circle6, Polyline4_5, Polyline18_9, Circle2_9, Polyline85, Polyline6_5, Circle2_10, Polyline18_10, Polyline23_5, Circle2_1_5, Polyline18_1_5, Polyline86..Polyline90, Circle7, Polyline4_6, Polyline18_11, Circle2_11, Polyline91, Polyline6_6, Circle2_12, Polyline18_12, Polyline23_6, Circle2_1_6, Polyline18_1_6, Polyline92, Polyline93].move(Size_SB/2, -Size_SB/2, 0mm)
  Box4 [Rogers RT/duroid 5880 (tm)] = box(corner=(-Size_SB/2, -Size_SB/2, 0mm), size=(Size_SB, Size_SB, h0))
  Polyline116 [copper] = polyline((x0, -y0, h0) (x0+w1, -y0, h0))
  Polyline128 = polyline(z=h0, xy: (x0, -y0) (x0, -y0+r0+s3+w1) (x0+l3, -y0+r0+s3+w1) (x0+l3, -y0+r0+s3+w1+s1) (x0+l3-l2, -y0+r0+s3+w1+s1) (x0+l3-l2, -y0+r0+s3+w1+s1+2*w1+s1) (x0+l3, -y0+r0+s3+w1+s1+2*w1+s1) (x0+l3, -y0+r0+s3+w1+s1+2*w1+2*s1) (x0+l3-l1, -y0+r0+s3+w1+s1+2*w1+2*s1) (x0+l3-l1, -y0+r0+s3+w1+s1+4*w1+3*s1) (Size_SB/2-w0, -y0+r0+s3+w1+s1+4*w1+3*s1))
  Polyline116.sweep_along_path(Polyline128)
  Top_Red6 = circle(normal=Z, centre=(x0, -y0, h0), radius=r0)
  Polyline116.unite(Top_Red6)
  Polyline130 = polyline((0.83mm, 0.45mm, 0.254mm) (0.83mm, 0.45mm, h0+thick1))
  Polyline116.sweep_along_path(Polyline130)
  Polyline4_7 [copper] = Polyline116.duplicate_around_axis(axis=Z, angle=180deg, total=2)
  Polyline117 [copper] = polyline((Size_SB/2-w0, -y0+r0+s3+w1+s1+3*w1+3*s1, h0) (Size_SB/2, -y0+r0+s3+w1+s1+3*w1+3*s1, h0))
  Polyline129 = polyline((Size_SB/2-w0/2, -y0+r0+s3+w1+s1+3*w1+3*s1+w1, h0) (Size_SB/2-w0/2, d1/2, h0))
  Polyline117.sweep_along_path(Polyline129)
  Polyline132 = polyline((Size_SB/2-w0/2, -y0+r0+s3+w1+s1+3*w1+3*s1, h0) (Size_SB/2-w0/2, -y0+r0+s3+w1+s1+3*w1+3*s1, h0+thick1))
  Polyline117.sweep_along_path(Polyline132)
  Polyline6_7 [copper] = Polyline117.duplicate_around_axis(axis=Z, angle=180deg, total=2)
  Polyline118 [copper] = polyline((Size_SB/2, -r1, h0) (Size_SB/2, -d1/2, h0))
  Polyline131 = polyline((Size_SB/2, -r1+(r1-d1/2)/2, h0) (2mm, 1.4936989e-17mm, 0.254mm) (2.15mm, 0.15mm, 0.254mm), AngularArc from point 0 over 3 centre=(Size_SB/2, 0mm, h0) angle=-180deg plane=XY)
  Polyline118.sweep_along_path(Polyline131)
  Polyline118.thicken(0.026mm)
  Polyline18_13 [copper] = Polyline118.duplicate_around_axis(axis=Z, angle=90deg, total=2)
  Polyline18_14 [copper] = Polyline118.duplicate_around_axis(axis=Z, angle=180deg, total=2)
  Circle8 [copper] = circle(normal=Z, centre=(Size_SB/2, 0mm, h0), radius=d1/2)
  Rectangle7 = rectangle(corner=(Size_SB/2, -d1/2, h0), x_size=d1/2, y_size=d1)
  Circle8.subtract(Rectangle7)
  Circle8.thicken(0.026mm)
  Circle2_13 [copper] = Circle8.duplicate_around_axis(axis=Z, angle=90deg, total=2)
  Circle2_14 [copper] = Circle8.duplicate_around_axis(axis=Z, angle=180deg, total=2)
  Polyline18_1_7 [copper] = Polyline18_13.duplicate_around_axis(axis=Z, angle=180deg, total=2)
  Circle2_1_7 [copper] = Circle2_13.duplicate_around_axis(axis=Z, angle=180deg, total=2)
  Polyline119 [copper] = polyline((-d1/2, Size_SB/2-w0, h0) (-d1/2, Size_SB/2, h0))
  Polyline133 = polyline((-Size_SB/2, Size_SB/2-w0/2, h0) (-d1/2, Size_SB/2-w0/2, h0))
  Polyline119.sweep_along_path(Polyline133)
  Polyline134 = polyline((-0.6125mm, 2.15mm, 0.254mm) (-0.6125mm, 2.15mm, h0 + thick1))
  Polyline119.sweep_along_path(Polyline134)
  Polyline23_7 [copper] = Polyline119.duplicate_around_axis(axis=Z, angle=180deg, total=2)
  Polyline6_7.rotate(axis=X, angle=180deg)
  Polyline6_7.rotate(axis=Y, angle=180deg)
  Polyline6_7.rotate(axis=Z, angle=180deg)
  Polyline6_7.rotate(axis=X, angle=180deg)
  Polyline6_7.move(0mm, 0mm, 2*h0+thick1)
  Circle2_14.rotate(axis=X, angle=180deg)
  Circle2_14.rotate(axis=Y, angle=180deg)
  Circle2_14.rotate(axis=Z, angle=180deg)
  Circle2_14.rotate(axis=X, angle=180deg)
  Circle2_14.move(0mm, 0mm, 2*h0+thick1)
  Polyline18_14.rotate(axis=X, angle=180deg)
  Polyline18_14.rotate(axis=Y, angle=180deg)
  Polyline18_14.rotate(axis=Z, angle=180deg)
  Polyline18_14.rotate(axis=X, angle=180deg)
  Polyline18_14.move(0mm, 0mm, 2*h0+thick1)
  Polyline23_7.rotate(axis=Y, angle=180deg)
  Polyline23_7.move(0mm, 0mm, 2*h0+thick1)
  Circle2_1_7.rotate(axis=Y, angle=180deg)
  Circle2_1_7.move(0mm, 0mm, 2*h0+thick1)
  Polyline18_1_7.rotate(axis=Y, angle=180deg)
  Polyline18_1_7.move(0mm, 0mm, 2*h0+thick1)
  Polyline120 [copper] = polyline((-Size_SB/2, -Size_SB/2+w0, h0) (-Size_SB/2+w0, -Size_SB/2+w0, h0))
  Polyline135 = polyline((-Size_SB/2+w0/2, -Size_SB/2+w0, h0) (-Size_SB/2+w0/2, -Size_SB/2+s0+w1, h0))
  Polyline120.sweep_along_path(Polyline135)
  Polyline136 = polyline((-Size_SB/2+w0, -Size_SB/2+w0, h0) (-Size_SB/2+w0, -Size_SB/2+w0, h0+thick1))
  Polyline120.sweep_along_path(Polyline136)
  Polyline121 [copper] = polyline((Size_SB/2-w0, -Size_SB/2+left_bottom, h0) (Size_SB/2, -Size_SB/2+left_bottom, h0))
  Polyline137 = polyline((Size_SB/2-w0/2, -Size_SB/2, h0) (Size_SB/2-w0/2, -Size_SB/2+left_bottom, h0))
  Polyline121.sweep_along_path(Polyline137)
  Polyline138 = polyline((Size_SB/2-w0/2, -Size_SB/2+left_bottom, h0) (Size_SB/2-w0/2, -Size_SB/2+left_bottom, h0+thick1))
  Polyline121.sweep_along_path(Polyline138)
  Polyline122 [copper] = polyline((x0, -y0, h0) (x0+w1, -y0, h0))
  Polyline139 = polyline(z=h0, xy: (x0, -y0) (x0, -y0+r0+s3+w1) (x0+l3, -y0+r0+s3+w1) (x0+l3, -y0+r0+s3+w1+s1) (x0+l3-l2, -y0+r0+s3+w1+s1) (x0+l3-l2, -y0+r0+s3+w1+s1+2*w1+s1) (x0+l3, -y0+r0+s3+w1+s1+2*w1+s1) (x0+l3, -y0+r0+s3+w1+s1+2*w1+2*s1) (x0+l3-l1, -y0+r0+s3+w1+s1+2*w1+2*s1) (x0+l3-l1, -y0+r0+s3+w1+s1+4*w1+3*s1) (Size_SB/2-w0, -y0+r0+s3+w1+s1+4*w1+3*s1))
  Polyline122.sweep_along_path(Polyline139)
  Top_Red7 = circle(normal=Z, centre=(x0, -y0, h0), radius=r0)
  Polyline122.unite(Top_Red7)
  Polyline141 = polyline((0.83mm, 0.45mm, 0.254mm) (0.83mm, 0.45mm, h0+thick1))
  Polyline122.sweep_along_path(Polyline141)
  Polyline4_8 [copper] = Polyline122.duplicate_around_axis(axis=Z, angle=180deg, total=2)
  Polyline122.mirror(point=(0mm, 0mm, 0.254mm), normal=(1mm, 1mm, 0mm))
  Polyline122.rotate(axis=Z, angle=180deg)
  Polyline122.rotate(axis=X, angle=180deg)
  Polyline122.rotate(axis=Z, angle=180deg)
  Polyline122.move(0mm, 0mm, h0)
  Polyline123 [copper] = polyline((Size_SB/2-w0, -y0+r0+s3+w1+s1+3*w1+3*s1, h0) (Size_SB/2, -y0+r0+s3+w1+s1+3*w1+3*s1, h0))
  Polyline140 = polyline((Size_SB/2-w0/2, -y0+r0+s3+w1+s1+3*w1+3*s1+w1, h0) (Size_SB/2-w0/2, d1/2, h0))
  Polyline123.sweep_along_path(Polyline140)
  Polyline143 = polyline((Size_SB/2-w0/2, -y0+r0+s3+w1+s1+3*w1+3*s1, h0) (Size_SB/2-w0/2, -y0+r0+s3+w1+s1+3*w1+3*s1, h0+thick1))
  Polyline123.sweep_along_path(Polyline143)
  Polyline6_8 [copper] = Polyline123.duplicate_around_axis(axis=Z, angle=180deg, total=2)
  Polyline123.mirror(point=(0mm, 0mm, 0.254mm), normal=(1mm, 1mm, 0mm))
  Polyline123.rotate(axis=Z, angle=180deg)
  Polyline123.rotate(axis=X, angle=180deg)
  Polyline123.rotate(axis=Z, angle=180deg)
  Polyline123.move(0mm, 0mm, h0)
  Polyline124 [copper] = polyline((Size_SB/2, -r1, h0) (Size_SB/2, -d1/2, h0))
  Polyline142 = polyline((Size_SB/2, -r1+(r1-d1/2)/2, h0) (2mm, 1.4936989e-17mm, 0.254mm) (2.15mm, 0.15mm, 0.254mm), AngularArc from point 0 over 3 centre=(Size_SB/2, 0mm, h0) angle=-180deg plane=XY)
  Polyline124.sweep_along_path(Polyline142)
  Polyline124.thicken(0.026mm)
  Polyline18_15 [copper] = Polyline124.duplicate_around_axis(axis=Z, angle=90deg, total=2)
  Polyline18_16 [copper] = Polyline124.duplicate_around_axis(axis=Z, angle=180deg, total=2)
  Polyline124.mirror(point=(0mm, 0mm, 0.254mm), normal=(1mm, 1mm, 0mm))
  Polyline124.rotate(axis=Z, angle=180deg)
  Polyline124.rotate(axis=X, angle=180deg)
  Polyline124.rotate(axis=Z, angle=180deg)
  Polyline124.move(0mm, 0mm, h0)
  Circle9 [copper] = circle(normal=Z, centre=(Size_SB/2, 0mm, h0), radius=d1/2)
  Rectangle8 = rectangle(corner=(Size_SB/2, -d1/2, h0), x_size=d1/2, y_size=d1)
  Circle9.subtract(Rectangle8)
  Circle9.thicken(0.026mm)
  Circle2_15 [copper] = Circle9.duplicate_around_axis(axis=Z, angle=90deg, total=2)
  Circle2_16 [copper] = Circle9.duplicate_around_axis(axis=Z, angle=180deg, total=2)
  Circle9.mirror(point=(0mm, 0mm, 0.254mm), normal=(1mm, 1mm, 0mm))
  Circle9.rotate(axis=Z, angle=180deg)
  Circle9.rotate(axis=X, angle=180deg)
  Circle9.rotate(axis=Z, angle=180deg)
  Circle9.move(0mm, 0mm, h0)
  Polyline4_8.mirror(point=(0mm, 0mm, 0.254mm), normal=(1mm, 1mm, 0mm))
  Polyline4_8.rotate(axis=Z, angle=180deg)
  Polyline4_8.rotate(axis=X, angle=180deg)
  Polyline4_8.rotate(axis=Z, angle=180deg)
  Polyline4_8.move(0mm, 0mm, h0)
  Polyline18_1_8 [copper] = Polyline18_15.duplicate_around_axis(axis=Z, angle=180deg, total=2)
  Polyline18_15.mirror(point=(0mm, 0mm, 0.254mm), normal=(1mm, 1mm, 0mm))
  Polyline18_15.rotate(axis=Z, angle=180deg)
  Polyline18_15.rotate(axis=X, angle=180deg)
  Polyline18_15.rotate(axis=Z, angle=180deg)
  Polyline18_15.move(0mm, 0mm, h0)
  Circle2_1_8 [copper] = Circle2_15.duplicate_around_axis(axis=Z, angle=180deg, total=2)
  Circle2_15.mirror(point=(0mm, 0mm, 0.254mm), normal=(1mm, 1mm, 0mm))
  Circle2_15.rotate(axis=Z, angle=180deg)
  Circle2_15.rotate(axis=X, angle=180deg)
  Circle2_15.rotate(axis=Z, angle=180deg)
  Circle2_15.move(0mm, 0mm, h0)
  Polyline125 [copper] = polyline((-d1/2, Size_SB/2-w0, h0) (-d1/2, Size_SB/2, h0))
  Polyline144 = polyline((-Size_SB/2, Size_SB/2-w0/2, h0) (-d1/2, Size_SB/2-w0/2, h0))
  Polyline125.sweep_along_path(Polyline144)
  Polyline145 = polyline((-0.6125mm, 2.15mm, 0.254mm) (-0.6125mm, 2.15mm, h0 + thick1))
  Polyline125.sweep_along_path(Polyline145)
  Polyline23_8 [copper] = Polyline125.duplicate_around_axis(axis=Z, angle=180deg, total=2)
  Polyline125.mirror(point=(0mm, 0mm, 0.254mm), normal=(1mm, 1mm, 0mm))
  Polyline125.rotate(axis=Z, angle=180deg)
  Polyline125.rotate(axis=X, angle=180deg)
  Polyline125.rotate(axis=Z, angle=180deg)
  Polyline125.move(0mm, 0mm, h0)
  Polyline6_8.rotate(axis=X, angle=180deg)
  Polyline6_8.rotate(axis=Y, angle=180deg)
  Polyline6_8.rotate(axis=Z, angle=180deg)
  Polyline6_8.rotate(axis=X, angle=180deg)
  Polyline6_8.move(0mm, 0mm, 2*h0+thick1)
  Polyline6_8.mirror(point=(0mm, 0mm, 0.254mm), normal=(1mm, 1mm, 0mm))
  Polyline6_8.rotate(axis=Z, angle=180deg)
  Polyline6_8.rotate(axis=X, angle=180deg)
  Polyline6_8.rotate(axis=Z, angle=180deg)
  Polyline6_8.move(0mm, 0mm, h0)
  Circle2_16.rotate(axis=X, angle=180deg)
  Circle2_16.rotate(axis=Y, angle=180deg)
  Circle2_16.rotate(axis=Z, angle=180deg)
  Circle2_16.rotate(axis=X, angle=180deg)
  Circle2_16.move(0mm, 0mm, 2*h0+thick1)
  Circle2_16.mirror(point=(0mm, 0mm, 0.254mm), normal=(1mm, 1mm, 0mm))
  Circle2_16.rotate(axis=Z, angle=180deg)
  Circle2_16.rotate(axis=X, angle=180deg)
  Circle2_16.rotate(axis=Z, angle=180deg)
  Circle2_16.move(0mm, 0mm, h0)
  Polyline18_16.rotate(axis=X, angle=180deg)
  Polyline18_16.rotate(axis=Y, angle=180deg)
  Polyline18_16.rotate(axis=Z, angle=180deg)
  Polyline18_16.rotate(axis=X, angle=180deg)
  Polyline18_16.move(0mm, 0mm, 2*h0+thick1)
  Polyline18_16.mirror(point=(0mm, 0mm, 0.254mm), normal=(1mm, 1mm, 0mm))
  Polyline18_16.rotate(axis=Z, angle=180deg)
  Polyline18_16.rotate(axis=X, angle=180deg)
  Polyline18_16.rotate(axis=Z, angle=180deg)
  Polyline18_16.move(0mm, 0mm, h0)
  Polyline23_8.rotate(axis=Y, angle=180deg)
  Polyline23_8.move(0mm, 0mm, 2*h0+thick1)
  Polyline23_8.mirror(point=(0mm, 0mm, 0.254mm), normal=(1mm, 1mm, 0mm))
  Polyline23_8.rotate(axis=Z, angle=180deg)
  Polyline23_8.rotate(axis=X, angle=180deg)
  Polyline23_8.rotate(axis=Z, angle=180deg)
  Polyline23_8.move(0mm, 0mm, h0)
  Circle2_1_8.rotate(axis=Y, angle=180deg)
  Circle2_1_8.move(0mm, 0mm, 2*h0+thick1)
  Circle2_1_8.mirror(point=(0mm, 0mm, 0.254mm), normal=(1mm, 1mm, 0mm))
  Circle2_1_8.rotate(axis=Z, angle=180deg)
  Circle2_1_8.rotate(axis=X, angle=180deg)
  Circle2_1_8.rotate(axis=Z, angle=180deg)
  Circle2_1_8.move(0mm, 0mm, h0)
  Polyline18_1_8.rotate(axis=Y, angle=180deg)
  Polyline18_1_8.move(0mm, 0mm, 2*h0+thick1)
  Polyline18_1_8.mirror(point=(0mm, 0mm, 0.254mm), normal=(1mm, 1mm, 0mm))
  Polyline18_1_8.rotate(axis=Z, angle=180deg)
  Polyline18_1_8.rotate(axis=X, angle=180deg)
  Polyline18_1_8.rotate(axis=Z, angle=180deg)
  Polyline18_1_8.move(0mm, 0mm, h0)
  Polyline126 [copper] = polyline((-Size_SB/2, -Size_SB/2+w0, h0) (-Size_SB/2+w0, -Size_SB/2+w0, h0))
  Polyline146 = polyline((-Size_SB/2+w0/2, -Size_SB/2+w0, h0) (-Size_SB/2+w0/2, -Size_SB/2+s0+w1, h0))
  Polyline126.sweep_along_path(Polyline146)
  Polyline147 = polyline((-Size_SB/2+w0, -Size_SB/2+w0, h0) (-Size_SB/2+w0, -Size_SB/2+w0, h0+thick1))
  Polyline126.sweep_along_path(Polyline147)
  Polyline126.mirror(point=(0mm, 0mm, 0.254mm), normal=(1mm, 1mm, 0mm))
  Polyline126.rotate(axis=Z, angle=180deg)
  Polyline126.rotate(axis=X, angle=180deg)
  Polyline126.rotate(axis=Z, angle=180deg)
  Polyline126.move(0mm, 0mm, h0)
  Polyline127 [copper] = polyline((Size_SB/2-w0, -Size_SB/2+left_bottom, h0) (Size_SB/2, -Size_SB/2+left_bottom, h0))
  Polyline148 = polyline((Size_SB/2-w0/2, -Size_SB/2, h0) (Size_SB/2-w0/2, -Size_SB/2+left_bottom, h0))
  Polyline127.sweep_along_path(Polyline148)
  Polyline149 = polyline((Size_SB/2-w0/2, -Size_SB/2+left_bottom, h0) (Size_SB/2-w0/2, -Size_SB/2+left_bottom, h0+thick1))
  Polyline127.sweep_along_path(Polyline149)
  Polyline127.mirror(point=(0mm, 0mm, 0.254mm), normal=(1mm, 1mm, 0mm))
  Polyline127.rotate(axis=Z, angle=180deg)
  Polyline127.rotate(axis=X, angle=180deg)
  Polyline127.rotate(axis=Z, angle=180deg)
  Polyline127.move(0mm, 0mm, h0)
  [Box4, Polyline116, Polyline117, Polyline118, Circle8, Polyline4_7, Polyline18_13, Circle2_13, Polyline119, Polyline6_7, Circle2_14, Polyline18_14, Polyline23_7, Circle2_1_7, Polyline18_1_7, Polyline120..Polyline124, Circle9, Polyline4_8, Polyline18_15, Circle2_15, Polyline125, Polyline6_8, Circle2_16, Polyline18_16, Polyline23_8, Circle2_1_8, Polyline18_1_8, Polyline126, Polyline127].move(Size_SB/2, Size_SB/2, 0mm)
